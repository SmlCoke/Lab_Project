*****************************************************
* Lab3 - Task 3: Use Logical Effort to Optimize 5×32 Decoder
*****************************************************
* global configuration
.option post=2 RUNLVL = 6
.temp 25
.param SUPPLY = 0.75
.param Lg = 20n

* lib
.include '../../16nfet.pm'
.include '../../16pfet.pm'

* source
Vdd vdd 0 DC 'SUPPLY'
VA4 A4 0 DC '0'
VA3 A3 0 DC '0'
VA2 A2 0 DC '0'
VA1 A1 0 PULSE (0 'SUPPLY' 900p 100p 100p 900p 2n)
VA0 A0 0 DC '0'

* We believe that the bulk of all PMOS transistors should be connected to VDD, and the bulk of all NMOS transistors should be connected to GND.

* Sub circuit: INVerter definition
* CM到SN/SP转换: SN = CM, SP = CM
.subckt INV in out vdd gnd SN=1 SP=1 Lg=20n
Mn out in gnd gnd nfet L='Lg' NFIN ='SN'
Mp out in vdd vdd pfet L='Lg' NFIN ='SP'
.ends INV

* Sub circuit: 2-NAND
* g = 1.5
* CM到SN/SP转换: SN = CM/1.5*2, SP = CM/1.5
.subckt NAND2 in1 in2 out vdd gnd SN=1 SP=1 Lg=20n
* PUN
Mp1 out in1 vdd vdd pfet L='Lg' NFIN='SP'
Mp2 out in2 vdd vdd pfet L='Lg' NFIN='SP'
* PDN
Mn1 out in1 source1 gnd nfet L='Lg' NFIN='SN'
Mn2 source1 in2 gnd gnd nfet L='Lg' NFIN='SN'
.ends NAND2

* Sub circuit: 3-NOR
* g = 2
* CM到SN/SP转换: SN = CM/2, SP = CM/2*3
.subckt NOR3 in1 in2 in3 out vdd gnd SN=1 SP=1 Lg=20n
*PUN
Mp1 out in1 source_p1 vdd pfet L='Lg' NFIN='SP'
Mp2 source_p1 in2 source_p2 vdd pfet L='Lg' NFIN='SP'
Mp3 source_p2 in3 vdd vdd pfet L='Lg' NFIN='SP'
*PDN
Mn1 out in1 gnd gnd nfet L='Lg' NFIN='SN'
Mn2 out in2 gnd gnd nfet L='Lg' NFIN='SN'
Mn3 out in3 gnd gnd nfet L='Lg' NFIN='SN'
.ends NOR3

* Circuit: 5 to 32 decoder
* The first layer is 5 inverters. After this layer, we get 5 outputs
* which are NA4, NA3, NA2, NA1, NA0
Xinv41 A4 NA4 vdd gnd INV SN='1' SP='1' Lg = '20n'
Xinv31 A3 NA3 vdd gnd INV SN='1' SP='1' Lg = '20n'
Xinv21 A2 NA2 vdd gnd INV SN='1' SP='1' Lg = '20n'
Xinv11 A1 NA1 vdd gnd INV SN='1' SP='1' Lg = '20n'
Xinv01 A0 NA0 vdd gnd INV SN='1' SP='1' Lg = '20n'

* The second layer is 5 inverters. After this layer, we get 5 outputs
* which are PA4, PA3, PA2, PA1, PA0
Xinv42 NA4 PA4 vdd gnd INV SN='1' SP='1' Lg = '20n'
Xinv32 NA3 PA3 vdd gnd INV SN='1' SP='1' Lg = '20n'
Xinv22 NA2 PA2 vdd gnd INV SN='1' SP='1' Lg = '20n'
Xinv12 NA1 PA1 vdd gnd INV SN='1' SP='1' Lg = '20n'
Xinv02 NA0 PA0 vdd gnd INV SN='1' SP='1' Lg = '20n'

* The third layer is 8 NAND2 gates. After this layer, we get 9 outputs
* which is Cartesian Product of (PA4, NA4) with (PA3, NA3) and (PA2, NA2) with (PA1, NA1)
* and NPA0
* XinvPA0: INV, SN = SP = CM
XinvPA0 PA0 NPA0 vdd gnd INV SN='SN_XinvPA0' SP='SP_XinvPA0' Lg = '20n'

* NAND2: SN = int(CM/1.5*2+0.5), SP = int(CM/1.5+0.5)
XNAND2_0 NA2 NA1 NA2_NA1 vdd gnd NAND2 SN="SN_NAND2" SP="SP_NAND2" Lg = '20n'
XNAND2_1 NA2 PA1 NA2_PA1 vdd gnd NAND2 SN="SN_NAND2" SP="SP_NAND2" Lg = '20n'
XNAND2_2 PA2 NA1 PA2_NA1 vdd gnd NAND2 SN="SN_NAND2" SP="SP_NAND2" Lg = '20n'
XNAND2_3 PA2 PA1 PA2_PA1 vdd gnd NAND2 SN="SN_NAND2" SP="SP_NAND2" Lg = '20n'
XNAND2_4 NA4 NA3 NA4_NA3 vdd gnd NAND2 SN="SN_NAND2" SP="SP_NAND2" Lg = '20n'
XNAND2_5 NA4 PA3 NA4_PA3 vdd gnd NAND2 SN="SN_NAND2" SP="SP_NAND2" Lg = '20n'
XNAND2_6 PA4 NA3 PA4_NA3 vdd gnd NAND2 SN="SN_NAND2" SP="SP_NAND2" Lg = '20n'
XNAND2_7 PA4 PA3 PA4_PA3 vdd gnd NAND2 SN="SN_NAND2" SP="SP_NAND2" Lg = '20n'

* The last layer: 32 NOR3 gates (4×4×2 = 32 combinations)
* Format: NOR3(A4A3_combo, A2A1_combo, A0_signal)
* NOR3: SN = int(CM/2+0.5), SP = int(CM/2*3+0.5)

* A4A3 = 00 (NA4_NA3)
XNOR3_0  NA4_NA3 NA2_NA1 PA0  word_0  vdd gnd NOR3 SN="SN_NOR3" SP="SP_NOR3" Lg='20n'
XNOR3_1  NA4_NA3 NA2_NA1 NPA0 word_1  vdd gnd NOR3 SN="SN_NOR3" SP="SP_NOR3" Lg='20n'
XNOR3_2  NA4_NA3 NA2_PA1 PA0  word_2  vdd gnd NOR3 SN="SN_NOR3" SP="SP_NOR3" Lg='20n'
XNOR3_3  NA4_NA3 NA2_PA1 NPA0 word_3  vdd gnd NOR3 SN="SN_NOR3" SP="SP_NOR3" Lg='20n'
XNOR3_4  NA4_NA3 PA2_NA1 PA0  word_4  vdd gnd NOR3 SN="SN_NOR3" SP="SP_NOR3" Lg='20n'
XNOR3_5  NA4_NA3 PA2_NA1 NPA0 word_5  vdd gnd NOR3 SN="SN_NOR3" SP="SP_NOR3" Lg='20n'
XNOR3_6  NA4_NA3 PA2_PA1 PA0  word_6  vdd gnd NOR3 SN="SN_NOR3" SP="SP_NOR3" Lg='20n'
XNOR3_7  NA4_NA3 PA2_PA1 NPA0 word_7  vdd gnd NOR3 SN="SN_NOR3" SP="SP_NOR3" Lg='20n'

* A4A3 = 01 (NA4_PA3)
XNOR3_8  NA4_PA3 NA2_NA1 PA0  word_8  vdd gnd NOR3 SN="SN_NOR3" SP="SP_NOR3" Lg='20n'
XNOR3_9  NA4_PA3 NA2_NA1 NPA0 word_9  vdd gnd NOR3 SN="SN_NOR3" SP="SP_NOR3" Lg='20n'
XNOR3_10 NA4_PA3 NA2_PA1 PA0  word_10 vdd gnd NOR3 SN="SN_NOR3" SP="SP_NOR3" Lg='20n'
XNOR3_11 NA4_PA3 NA2_PA1 NPA0 word_11 vdd gnd NOR3 SN="SN_NOR3" SP="SP_NOR3" Lg='20n'
XNOR3_12 NA4_PA3 PA2_NA1 PA0  word_12 vdd gnd NOR3 SN="SN_NOR3" SP="SP_NOR3" Lg='20n'
XNOR3_13 NA4_PA3 PA2_NA1 NPA0 word_13 vdd gnd NOR3 SN="SN_NOR3" SP="SP_NOR3" Lg='20n'
XNOR3_14 NA4_PA3 PA2_PA1 PA0  word_14 vdd gnd NOR3 SN="SN_NOR3" SP="SP_NOR3" Lg='20n'
XNOR3_15 NA4_PA3 PA2_PA1 NPA0 word_15 vdd gnd NOR3 SN="SN_NOR3" SP="SP_NOR3" Lg='20n'

* A4A3 = 10 (PA4_NA3)
XNOR3_16 PA4_NA3 NA2_NA1 PA0  word_16 vdd gnd NOR3 SN="SN_NOR3" SP="SP_NOR3" Lg='20n'
XNOR3_17 PA4_NA3 NA2_NA1 NPA0 word_17 vdd gnd NOR3 SN="SN_NOR3" SP="SP_NOR3" Lg='20n'
XNOR3_18 PA4_NA3 NA2_PA1 PA0  word_18 vdd gnd NOR3 SN="SN_NOR3" SP="SP_NOR3" Lg='20n'
XNOR3_19 PA4_NA3 NA2_PA1 NPA0 word_19 vdd gnd NOR3 SN="SN_NOR3" SP="SP_NOR3" Lg='20n'
XNOR3_20 PA4_NA3 PA2_NA1 PA0  word_20 vdd gnd NOR3 SN="SN_NOR3" SP="SP_NOR3" Lg='20n'
XNOR3_21 PA4_NA3 PA2_NA1 NPA0 word_21 vdd gnd NOR3 SN="SN_NOR3" SP="SP_NOR3" Lg='20n'
XNOR3_22 PA4_NA3 PA2_PA1 PA0  word_22 vdd gnd NOR3 SN="SN_NOR3" SP="SP_NOR3" Lg='20n'
XNOR3_23 PA4_NA3 PA2_PA1 NPA0 word_23 vdd gnd NOR3 SN="SN_NOR3" SP="SP_NOR3" Lg='20n'

* A4A3 = 11 (PA4_PA3)
XNOR3_24 PA4_PA3 NA2_NA1 PA0  word_24 vdd gnd NOR3 SN="SN_NOR3" SP="SP_NOR3" Lg='20n'
XNOR3_25 PA4_PA3 NA2_NA1 NPA0 word_25 vdd gnd NOR3 SN="SN_NOR3" SP="SP_NOR3" Lg='20n'
XNOR3_26 PA4_PA3 NA2_PA1 PA0  word_26 vdd gnd NOR3 SN="SN_NOR3" SP="SP_NOR3" Lg='20n'
XNOR3_27 PA4_PA3 NA2_PA1 NPA0 word_27 vdd gnd NOR3 SN="SN_NOR3" SP="SP_NOR3" Lg='20n'
XNOR3_28 PA4_PA3 PA2_NA1 PA0  word_28 vdd gnd NOR3 SN="SN_NOR3" SP="SP_NOR3" Lg='20n'
XNOR3_29 PA4_PA3 PA2_NA1 NPA0 word_29 vdd gnd NOR3 SN="SN_NOR3" SP="SP_NOR3" Lg='20n'
XNOR3_30 PA4_PA3 PA2_PA1 PA0  word_30 vdd gnd NOR3 SN="SN_NOR3" SP="SP_NOR3" Lg='20n'
XNOR3_31 PA4_PA3 PA2_PA1 NPA0 word_31 vdd gnd NOR3 SN="SN_NOR3" SP="SP_NOR3" Lg='20n'

* About critical path H2 (A1 input path):
* A1 -> Xinv11 -> NA1 -> Xinv12 -> PA1 -> XNAND2_1 -> NA2_PA1 -> XNOR3_2 -> word_2
* H2min = 12288
* P = (m+3)12288**[1/(m+3)] + m + 6 = N12288**(1/N) + N + 3

* Buffer inverters (m=4), INV: SN = SP = CM
Xbuffer_0 word_2 buffer_out_0 vdd gnd INV SN='SN_buffer_0' SP='SN_buffer_0' Lg='20n'
Xbuffer_1 buffer_out_0 buffer_out_1 vdd gnd INV SN='SN_buffer_1' SP='SN_buffer_1' Lg='20n'
Xbuffer_2 buffer_out_1 buffer_out_2 vdd gnd INV SN='SN_buffer_2' SP='SN_buffer_2' Lg='20n'
Xbuffer_3 buffer_out_2 buffer_out_3 vdd gnd INV SN='SN_buffer_3' SP='SN_buffer_3' Lg='20n'
Xinv_load buffer_out_3 load_out vdd gnd INV SN='256' SP='256' Lg='20n'
.data sweepdata SN_XinvPA0 SP_XinvPA0 SN_NAND2 SP_NAND2 SN_NOR3 SP_NOR3 SN_buffer_0 SP_buffer_0 SN_buffer_1 SP_buffer_1 SN_buffer_2 SP_buffer_2 SN_buffer_3 SP_buffer_3
+ 1 1 2 1 1 3 1 1 4 4 15 15 63 63
+ 1 1 2 1 1 3 1 1 4 4 15 15 65 65
+ 1 1 2 1 1 3 1 1 4 4 15 15 67 67
+ 1 1 2 1 1 3 1 1 4 4 15 15 69 69
+ 1 1 2 1 1 3 1 1 4 4 15 15 71 71
+ 1 1 2 1 1 3 1 1 4 4 17 17 63 63
+ 1 1 2 1 1 3 1 1 4 4 17 17 65 65
+ 1 1 2 1 1 3 1 1 4 4 17 17 67 67
+ 1 1 2 1 1 3 1 1 4 4 17 17 69 69
+ 1 1 2 1 1 3 1 1 4 4 17 17 71 71
+ 1 1 2 1 1 3 1 1 4 4 19 19 63 63
+ 1 1 2 1 1 3 1 1 4 4 19 19 65 65
+ 1 1 2 1 1 3 1 1 4 4 19 19 67 67
+ 1 1 2 1 1 3 1 1 4 4 19 19 69 69
+ 1 1 2 1 1 3 1 1 4 4 19 19 71 71
+ 1 1 2 1 1 3 1 1 5 5 15 15 63 63
+ 1 1 2 1 1 3 1 1 5 5 15 15 65 65
+ 1 1 2 1 1 3 1 1 5 5 15 15 67 67
+ 1 1 2 1 1 3 1 1 5 5 15 15 69 69
+ 1 1 2 1 1 3 1 1 5 5 15 15 71 71
+ 1 1 2 1 1 3 1 1 5 5 17 17 63 63
+ 1 1 2 1 1 3 1 1 5 5 17 17 65 65
+ 1 1 2 1 1 3 1 1 5 5 17 17 67 67
+ 1 1 2 1 1 3 1 1 5 5 17 17 69 69
+ 1 1 2 1 1 3 1 1 5 5 17 17 71 71
+ 1 1 2 1 1 3 1 1 5 5 19 19 63 63
+ 1 1 2 1 1 3 1 1 5 5 19 19 65 65
+ 1 1 2 1 1 3 1 1 5 5 19 19 67 67
+ 1 1 2 1 1 3 1 1 5 5 19 19 69 69
+ 1 1 2 1 1 3 1 1 5 5 19 19 71 71
+ 1 1 2 1 1 3 1 1 6 6 15 15 63 63
+ 1 1 2 1 1 3 1 1 6 6 15 15 65 65
+ 1 1 2 1 1 3 1 1 6 6 15 15 67 67
+ 1 1 2 1 1 3 1 1 6 6 15 15 69 69
+ 1 1 2 1 1 3 1 1 6 6 15 15 71 71
+ 1 1 2 1 1 3 1 1 6 6 17 17 63 63
+ 1 1 2 1 1 3 1 1 6 6 17 17 65 65
+ 1 1 2 1 1 3 1 1 6 6 17 17 67 67
+ 1 1 2 1 1 3 1 1 6 6 17 17 69 69
+ 1 1 2 1 1 3 1 1 6 6 17 17 71 71
+ 1 1 2 1 1 3 1 1 6 6 19 19 63 63
+ 1 1 2 1 1 3 1 1 6 6 19 19 65 65
+ 1 1 2 1 1 3 1 1 6 6 19 19 67 67
+ 1 1 2 1 1 3 1 1 6 6 19 19 69 69
+ 1 1 2 1 1 3 1 1 6 6 19 19 71 71
+ 1 1 2 1 1 3 2 2 4 4 15 15 63 63
+ 1 1 2 1 1 3 2 2 4 4 15 15 65 65
+ 1 1 2 1 1 3 2 2 4 4 15 15 67 67
+ 1 1 2 1 1 3 2 2 4 4 15 15 69 69
+ 1 1 2 1 1 3 2 2 4 4 15 15 71 71
+ 1 1 2 1 1 3 2 2 4 4 17 17 63 63
+ 1 1 2 1 1 3 2 2 4 4 17 17 65 65
+ 1 1 2 1 1 3 2 2 4 4 17 17 67 67
+ 1 1 2 1 1 3 2 2 4 4 17 17 69 69
+ 1 1 2 1 1 3 2 2 4 4 17 17 71 71
+ 1 1 2 1 1 3 2 2 4 4 19 19 63 63
+ 1 1 2 1 1 3 2 2 4 4 19 19 65 65
+ 1 1 2 1 1 3 2 2 4 4 19 19 67 67
+ 1 1 2 1 1 3 2 2 4 4 19 19 69 69
+ 1 1 2 1 1 3 2 2 4 4 19 19 71 71
+ 1 1 2 1 1 3 2 2 5 5 15 15 63 63
+ 1 1 2 1 1 3 2 2 5 5 15 15 65 65
+ 1 1 2 1 1 3 2 2 5 5 15 15 67 67
+ 1 1 2 1 1 3 2 2 5 5 15 15 69 69
+ 1 1 2 1 1 3 2 2 5 5 15 15 71 71
+ 1 1 2 1 1 3 2 2 5 5 17 17 63 63
+ 1 1 2 1 1 3 2 2 5 5 17 17 65 65
+ 1 1 2 1 1 3 2 2 5 5 17 17 67 67
+ 1 1 2 1 1 3 2 2 5 5 17 17 69 69
+ 1 1 2 1 1 3 2 2 5 5 17 17 71 71
+ 1 1 2 1 1 3 2 2 5 5 19 19 63 63
+ 1 1 2 1 1 3 2 2 5 5 19 19 65 65
+ 1 1 2 1 1 3 2 2 5 5 19 19 67 67
+ 1 1 2 1 1 3 2 2 5 5 19 19 69 69
+ 1 1 2 1 1 3 2 2 5 5 19 19 71 71
+ 1 1 2 1 1 3 2 2 6 6 15 15 63 63
+ 1 1 2 1 1 3 2 2 6 6 15 15 65 65
+ 1 1 2 1 1 3 2 2 6 6 15 15 67 67
+ 1 1 2 1 1 3 2 2 6 6 15 15 69 69
+ 1 1 2 1 1 3 2 2 6 6 15 15 71 71
+ 1 1 2 1 1 3 2 2 6 6 17 17 63 63
+ 1 1 2 1 1 3 2 2 6 6 17 17 65 65
+ 1 1 2 1 1 3 2 2 6 6 17 17 67 67
+ 1 1 2 1 1 3 2 2 6 6 17 17 69 69
+ 1 1 2 1 1 3 2 2 6 6 17 17 71 71
+ 1 1 2 1 1 3 2 2 6 6 19 19 63 63
+ 1 1 2 1 1 3 2 2 6 6 19 19 65 65
+ 1 1 2 1 1 3 2 2 6 6 19 19 67 67
+ 1 1 2 1 1 3 2 2 6 6 19 19 69 69
+ 1 1 2 1 1 3 2 2 6 6 19 19 71 71
+ 1 1 2 1 2 6 1 1 4 4 15 15 63 63
+ 1 1 2 1 2 6 1 1 4 4 15 15 65 65
+ 1 1 2 1 2 6 1 1 4 4 15 15 67 67
+ 1 1 2 1 2 6 1 1 4 4 15 15 69 69
+ 1 1 2 1 2 6 1 1 4 4 15 15 71 71
+ 1 1 2 1 2 6 1 1 4 4 17 17 63 63
+ 1 1 2 1 2 6 1 1 4 4 17 17 65 65
+ 1 1 2 1 2 6 1 1 4 4 17 17 67 67
+ 1 1 2 1 2 6 1 1 4 4 17 17 69 69
+ 1 1 2 1 2 6 1 1 4 4 17 17 71 71
+ 1 1 2 1 2 6 1 1 4 4 19 19 63 63
+ 1 1 2 1 2 6 1 1 4 4 19 19 65 65
+ 1 1 2 1 2 6 1 1 4 4 19 19 67 67
+ 1 1 2 1 2 6 1 1 4 4 19 19 69 69
+ 1 1 2 1 2 6 1 1 4 4 19 19 71 71
+ 1 1 2 1 2 6 1 1 5 5 15 15 63 63
+ 1 1 2 1 2 6 1 1 5 5 15 15 65 65
+ 1 1 2 1 2 6 1 1 5 5 15 15 67 67
+ 1 1 2 1 2 6 1 1 5 5 15 15 69 69
+ 1 1 2 1 2 6 1 1 5 5 15 15 71 71
+ 1 1 2 1 2 6 1 1 5 5 17 17 63 63
+ 1 1 2 1 2 6 1 1 5 5 17 17 65 65
+ 1 1 2 1 2 6 1 1 5 5 17 17 67 67
+ 1 1 2 1 2 6 1 1 5 5 17 17 69 69
+ 1 1 2 1 2 6 1 1 5 5 17 17 71 71
+ 1 1 2 1 2 6 1 1 5 5 19 19 63 63
+ 1 1 2 1 2 6 1 1 5 5 19 19 65 65
+ 1 1 2 1 2 6 1 1 5 5 19 19 67 67
+ 1 1 2 1 2 6 1 1 5 5 19 19 69 69
+ 1 1 2 1 2 6 1 1 5 5 19 19 71 71
+ 1 1 2 1 2 6 1 1 6 6 15 15 63 63
+ 1 1 2 1 2 6 1 1 6 6 15 15 65 65
+ 1 1 2 1 2 6 1 1 6 6 15 15 67 67
+ 1 1 2 1 2 6 1 1 6 6 15 15 69 69
+ 1 1 2 1 2 6 1 1 6 6 15 15 71 71
+ 1 1 2 1 2 6 1 1 6 6 17 17 63 63
+ 1 1 2 1 2 6 1 1 6 6 17 17 65 65
+ 1 1 2 1 2 6 1 1 6 6 17 17 67 67
+ 1 1 2 1 2 6 1 1 6 6 17 17 69 69
+ 1 1 2 1 2 6 1 1 6 6 17 17 71 71
+ 1 1 2 1 2 6 1 1 6 6 19 19 63 63
+ 1 1 2 1 2 6 1 1 6 6 19 19 65 65
+ 1 1 2 1 2 6 1 1 6 6 19 19 67 67
+ 1 1 2 1 2 6 1 1 6 6 19 19 69 69
+ 1 1 2 1 2 6 1 1 6 6 19 19 71 71
+ 1 1 2 1 2 6 2 2 4 4 15 15 63 63
+ 1 1 2 1 2 6 2 2 4 4 15 15 65 65
+ 1 1 2 1 2 6 2 2 4 4 15 15 67 67
+ 1 1 2 1 2 6 2 2 4 4 15 15 69 69
+ 1 1 2 1 2 6 2 2 4 4 15 15 71 71
+ 1 1 2 1 2 6 2 2 4 4 17 17 63 63
+ 1 1 2 1 2 6 2 2 4 4 17 17 65 65
+ 1 1 2 1 2 6 2 2 4 4 17 17 67 67
+ 1 1 2 1 2 6 2 2 4 4 17 17 69 69
+ 1 1 2 1 2 6 2 2 4 4 17 17 71 71
+ 1 1 2 1 2 6 2 2 4 4 19 19 63 63
+ 1 1 2 1 2 6 2 2 4 4 19 19 65 65
+ 1 1 2 1 2 6 2 2 4 4 19 19 67 67
+ 1 1 2 1 2 6 2 2 4 4 19 19 69 69
+ 1 1 2 1 2 6 2 2 4 4 19 19 71 71
+ 1 1 2 1 2 6 2 2 5 5 15 15 63 63
+ 1 1 2 1 2 6 2 2 5 5 15 15 65 65
+ 1 1 2 1 2 6 2 2 5 5 15 15 67 67
+ 1 1 2 1 2 6 2 2 5 5 15 15 69 69
+ 1 1 2 1 2 6 2 2 5 5 15 15 71 71
+ 1 1 2 1 2 6 2 2 5 5 17 17 63 63
+ 1 1 2 1 2 6 2 2 5 5 17 17 65 65
+ 1 1 2 1 2 6 2 2 5 5 17 17 67 67
+ 1 1 2 1 2 6 2 2 5 5 17 17 69 69
+ 1 1 2 1 2 6 2 2 5 5 17 17 71 71
+ 1 1 2 1 2 6 2 2 5 5 19 19 63 63
+ 1 1 2 1 2 6 2 2 5 5 19 19 65 65
+ 1 1 2 1 2 6 2 2 5 5 19 19 67 67
+ 1 1 2 1 2 6 2 2 5 5 19 19 69 69
+ 1 1 2 1 2 6 2 2 5 5 19 19 71 71
+ 1 1 2 1 2 6 2 2 6 6 15 15 63 63
+ 1 1 2 1 2 6 2 2 6 6 15 15 65 65
+ 1 1 2 1 2 6 2 2 6 6 15 15 67 67
+ 1 1 2 1 2 6 2 2 6 6 15 15 69 69
+ 1 1 2 1 2 6 2 2 6 6 15 15 71 71
+ 1 1 2 1 2 6 2 2 6 6 17 17 63 63
+ 1 1 2 1 2 6 2 2 6 6 17 17 65 65
+ 1 1 2 1 2 6 2 2 6 6 17 17 67 67
+ 1 1 2 1 2 6 2 2 6 6 17 17 69 69
+ 1 1 2 1 2 6 2 2 6 6 17 17 71 71
+ 1 1 2 1 2 6 2 2 6 6 19 19 63 63
+ 1 1 2 1 2 6 2 2 6 6 19 19 65 65
+ 1 1 2 1 2 6 2 2 6 6 19 19 67 67
+ 1 1 2 1 2 6 2 2 6 6 19 19 69 69
+ 1 1 2 1 2 6 2 2 6 6 19 19 71 71
+ 1 1 3 2 1 3 1 1 4 4 15 15 63 63
+ 1 1 3 2 1 3 1 1 4 4 15 15 65 65
+ 1 1 3 2 1 3 1 1 4 4 15 15 67 67
+ 1 1 3 2 1 3 1 1 4 4 15 15 69 69
+ 1 1 3 2 1 3 1 1 4 4 15 15 71 71
+ 1 1 3 2 1 3 1 1 4 4 17 17 63 63
+ 1 1 3 2 1 3 1 1 4 4 17 17 65 65
+ 1 1 3 2 1 3 1 1 4 4 17 17 67 67
+ 1 1 3 2 1 3 1 1 4 4 17 17 69 69
+ 1 1 3 2 1 3 1 1 4 4 17 17 71 71
+ 1 1 3 2 1 3 1 1 4 4 19 19 63 63
+ 1 1 3 2 1 3 1 1 4 4 19 19 65 65
+ 1 1 3 2 1 3 1 1 4 4 19 19 67 67
+ 1 1 3 2 1 3 1 1 4 4 19 19 69 69
+ 1 1 3 2 1 3 1 1 4 4 19 19 71 71
+ 1 1 3 2 1 3 1 1 5 5 15 15 63 63
+ 1 1 3 2 1 3 1 1 5 5 15 15 65 65
+ 1 1 3 2 1 3 1 1 5 5 15 15 67 67
+ 1 1 3 2 1 3 1 1 5 5 15 15 69 69
+ 1 1 3 2 1 3 1 1 5 5 15 15 71 71
+ 1 1 3 2 1 3 1 1 5 5 17 17 63 63
+ 1 1 3 2 1 3 1 1 5 5 17 17 65 65
+ 1 1 3 2 1 3 1 1 5 5 17 17 67 67
+ 1 1 3 2 1 3 1 1 5 5 17 17 69 69
+ 1 1 3 2 1 3 1 1 5 5 17 17 71 71
+ 1 1 3 2 1 3 1 1 5 5 19 19 63 63
+ 1 1 3 2 1 3 1 1 5 5 19 19 65 65
+ 1 1 3 2 1 3 1 1 5 5 19 19 67 67
+ 1 1 3 2 1 3 1 1 5 5 19 19 69 69
+ 1 1 3 2 1 3 1 1 5 5 19 19 71 71
+ 1 1 3 2 1 3 1 1 6 6 15 15 63 63
+ 1 1 3 2 1 3 1 1 6 6 15 15 65 65
+ 1 1 3 2 1 3 1 1 6 6 15 15 67 67
+ 1 1 3 2 1 3 1 1 6 6 15 15 69 69
+ 1 1 3 2 1 3 1 1 6 6 15 15 71 71
+ 1 1 3 2 1 3 1 1 6 6 17 17 63 63
+ 1 1 3 2 1 3 1 1 6 6 17 17 65 65
+ 1 1 3 2 1 3 1 1 6 6 17 17 67 67
+ 1 1 3 2 1 3 1 1 6 6 17 17 69 69
+ 1 1 3 2 1 3 1 1 6 6 17 17 71 71
+ 1 1 3 2 1 3 1 1 6 6 19 19 63 63
+ 1 1 3 2 1 3 1 1 6 6 19 19 65 65
+ 1 1 3 2 1 3 1 1 6 6 19 19 67 67
+ 1 1 3 2 1 3 1 1 6 6 19 19 69 69
+ 1 1 3 2 1 3 1 1 6 6 19 19 71 71
+ 1 1 3 2 1 3 2 2 4 4 15 15 63 63
+ 1 1 3 2 1 3 2 2 4 4 15 15 65 65
+ 1 1 3 2 1 3 2 2 4 4 15 15 67 67
+ 1 1 3 2 1 3 2 2 4 4 15 15 69 69
+ 1 1 3 2 1 3 2 2 4 4 15 15 71 71
+ 1 1 3 2 1 3 2 2 4 4 17 17 63 63
+ 1 1 3 2 1 3 2 2 4 4 17 17 65 65
+ 1 1 3 2 1 3 2 2 4 4 17 17 67 67
+ 1 1 3 2 1 3 2 2 4 4 17 17 69 69
+ 1 1 3 2 1 3 2 2 4 4 17 17 71 71
+ 1 1 3 2 1 3 2 2 4 4 19 19 63 63
+ 1 1 3 2 1 3 2 2 4 4 19 19 65 65
+ 1 1 3 2 1 3 2 2 4 4 19 19 67 67
+ 1 1 3 2 1 3 2 2 4 4 19 19 69 69
+ 1 1 3 2 1 3 2 2 4 4 19 19 71 71
+ 1 1 3 2 1 3 2 2 5 5 15 15 63 63
+ 1 1 3 2 1 3 2 2 5 5 15 15 65 65
+ 1 1 3 2 1 3 2 2 5 5 15 15 67 67
+ 1 1 3 2 1 3 2 2 5 5 15 15 69 69
+ 1 1 3 2 1 3 2 2 5 5 15 15 71 71
+ 1 1 3 2 1 3 2 2 5 5 17 17 63 63
+ 1 1 3 2 1 3 2 2 5 5 17 17 65 65
+ 1 1 3 2 1 3 2 2 5 5 17 17 67 67
+ 1 1 3 2 1 3 2 2 5 5 17 17 69 69
+ 1 1 3 2 1 3 2 2 5 5 17 17 71 71
+ 1 1 3 2 1 3 2 2 5 5 19 19 63 63
+ 1 1 3 2 1 3 2 2 5 5 19 19 65 65
+ 1 1 3 2 1 3 2 2 5 5 19 19 67 67
+ 1 1 3 2 1 3 2 2 5 5 19 19 69 69
+ 1 1 3 2 1 3 2 2 5 5 19 19 71 71
+ 1 1 3 2 1 3 2 2 6 6 15 15 63 63
+ 1 1 3 2 1 3 2 2 6 6 15 15 65 65
+ 1 1 3 2 1 3 2 2 6 6 15 15 67 67
+ 1 1 3 2 1 3 2 2 6 6 15 15 69 69
+ 1 1 3 2 1 3 2 2 6 6 15 15 71 71
+ 1 1 3 2 1 3 2 2 6 6 17 17 63 63
+ 1 1 3 2 1 3 2 2 6 6 17 17 65 65
+ 1 1 3 2 1 3 2 2 6 6 17 17 67 67
+ 1 1 3 2 1 3 2 2 6 6 17 17 69 69
+ 1 1 3 2 1 3 2 2 6 6 17 17 71 71
+ 1 1 3 2 1 3 2 2 6 6 19 19 63 63
+ 1 1 3 2 1 3 2 2 6 6 19 19 65 65
+ 1 1 3 2 1 3 2 2 6 6 19 19 67 67
+ 1 1 3 2 1 3 2 2 6 6 19 19 69 69
+ 1 1 3 2 1 3 2 2 6 6 19 19 71 71
+ 1 1 3 2 2 6 1 1 4 4 15 15 63 63
+ 1 1 3 2 2 6 1 1 4 4 15 15 65 65
+ 1 1 3 2 2 6 1 1 4 4 15 15 67 67
+ 1 1 3 2 2 6 1 1 4 4 15 15 69 69
+ 1 1 3 2 2 6 1 1 4 4 15 15 71 71
+ 1 1 3 2 2 6 1 1 4 4 17 17 63 63
+ 1 1 3 2 2 6 1 1 4 4 17 17 65 65
+ 1 1 3 2 2 6 1 1 4 4 17 17 67 67
+ 1 1 3 2 2 6 1 1 4 4 17 17 69 69
+ 1 1 3 2 2 6 1 1 4 4 17 17 71 71
+ 1 1 3 2 2 6 1 1 4 4 19 19 63 63
+ 1 1 3 2 2 6 1 1 4 4 19 19 65 65
+ 1 1 3 2 2 6 1 1 4 4 19 19 67 67
+ 1 1 3 2 2 6 1 1 4 4 19 19 69 69
+ 1 1 3 2 2 6 1 1 4 4 19 19 71 71
+ 1 1 3 2 2 6 1 1 5 5 15 15 63 63
+ 1 1 3 2 2 6 1 1 5 5 15 15 65 65
+ 1 1 3 2 2 6 1 1 5 5 15 15 67 67
+ 1 1 3 2 2 6 1 1 5 5 15 15 69 69
+ 1 1 3 2 2 6 1 1 5 5 15 15 71 71
+ 1 1 3 2 2 6 1 1 5 5 17 17 63 63
+ 1 1 3 2 2 6 1 1 5 5 17 17 65 65
+ 1 1 3 2 2 6 1 1 5 5 17 17 67 67
+ 1 1 3 2 2 6 1 1 5 5 17 17 69 69
+ 1 1 3 2 2 6 1 1 5 5 17 17 71 71
+ 1 1 3 2 2 6 1 1 5 5 19 19 63 63
+ 1 1 3 2 2 6 1 1 5 5 19 19 65 65
+ 1 1 3 2 2 6 1 1 5 5 19 19 67 67
+ 1 1 3 2 2 6 1 1 5 5 19 19 69 69
+ 1 1 3 2 2 6 1 1 5 5 19 19 71 71
+ 1 1 3 2 2 6 1 1 6 6 15 15 63 63
+ 1 1 3 2 2 6 1 1 6 6 15 15 65 65
+ 1 1 3 2 2 6 1 1 6 6 15 15 67 67
+ 1 1 3 2 2 6 1 1 6 6 15 15 69 69
+ 1 1 3 2 2 6 1 1 6 6 15 15 71 71
+ 1 1 3 2 2 6 1 1 6 6 17 17 63 63
+ 1 1 3 2 2 6 1 1 6 6 17 17 65 65
+ 1 1 3 2 2 6 1 1 6 6 17 17 67 67
+ 1 1 3 2 2 6 1 1 6 6 17 17 69 69
+ 1 1 3 2 2 6 1 1 6 6 17 17 71 71
+ 1 1 3 2 2 6 1 1 6 6 19 19 63 63
+ 1 1 3 2 2 6 1 1 6 6 19 19 65 65
+ 1 1 3 2 2 6 1 1 6 6 19 19 67 67
+ 1 1 3 2 2 6 1 1 6 6 19 19 69 69
+ 1 1 3 2 2 6 1 1 6 6 19 19 71 71
+ 1 1 3 2 2 6 2 2 4 4 15 15 63 63
+ 1 1 3 2 2 6 2 2 4 4 15 15 65 65
+ 1 1 3 2 2 6 2 2 4 4 15 15 67 67
+ 1 1 3 2 2 6 2 2 4 4 15 15 69 69
+ 1 1 3 2 2 6 2 2 4 4 15 15 71 71
+ 1 1 3 2 2 6 2 2 4 4 17 17 63 63
+ 1 1 3 2 2 6 2 2 4 4 17 17 65 65
+ 1 1 3 2 2 6 2 2 4 4 17 17 67 67
+ 1 1 3 2 2 6 2 2 4 4 17 17 69 69
+ 1 1 3 2 2 6 2 2 4 4 17 17 71 71
+ 1 1 3 2 2 6 2 2 4 4 19 19 63 63
+ 1 1 3 2 2 6 2 2 4 4 19 19 65 65
+ 1 1 3 2 2 6 2 2 4 4 19 19 67 67
+ 1 1 3 2 2 6 2 2 4 4 19 19 69 69
+ 1 1 3 2 2 6 2 2 4 4 19 19 71 71
+ 1 1 3 2 2 6 2 2 5 5 15 15 63 63
+ 1 1 3 2 2 6 2 2 5 5 15 15 65 65
+ 1 1 3 2 2 6 2 2 5 5 15 15 67 67
+ 1 1 3 2 2 6 2 2 5 5 15 15 69 69
+ 1 1 3 2 2 6 2 2 5 5 15 15 71 71
+ 1 1 3 2 2 6 2 2 5 5 17 17 63 63
+ 1 1 3 2 2 6 2 2 5 5 17 17 65 65
+ 1 1 3 2 2 6 2 2 5 5 17 17 67 67
+ 1 1 3 2 2 6 2 2 5 5 17 17 69 69
+ 1 1 3 2 2 6 2 2 5 5 17 17 71 71
+ 1 1 3 2 2 6 2 2 5 5 19 19 63 63
+ 1 1 3 2 2 6 2 2 5 5 19 19 65 65
+ 1 1 3 2 2 6 2 2 5 5 19 19 67 67
+ 1 1 3 2 2 6 2 2 5 5 19 19 69 69
+ 1 1 3 2 2 6 2 2 5 5 19 19 71 71
+ 1 1 3 2 2 6 2 2 6 6 15 15 63 63
+ 1 1 3 2 2 6 2 2 6 6 15 15 65 65
+ 1 1 3 2 2 6 2 2 6 6 15 15 67 67
+ 1 1 3 2 2 6 2 2 6 6 15 15 69 69
+ 1 1 3 2 2 6 2 2 6 6 15 15 71 71
+ 1 1 3 2 2 6 2 2 6 6 17 17 63 63
+ 1 1 3 2 2 6 2 2 6 6 17 17 65 65
+ 1 1 3 2 2 6 2 2 6 6 17 17 67 67
+ 1 1 3 2 2 6 2 2 6 6 17 17 69 69
+ 1 1 3 2 2 6 2 2 6 6 17 17 71 71
+ 1 1 3 2 2 6 2 2 6 6 19 19 63 63
+ 1 1 3 2 2 6 2 2 6 6 19 19 65 65
+ 1 1 3 2 2 6 2 2 6 6 19 19 67 67
+ 1 1 3 2 2 6 2 2 6 6 19 19 69 69
+ 1 1 3 2 2 6 2 2 6 6 19 19 71 71
+ 1 1 4 2 1 3 1 1 4 4 15 15 63 63
+ 1 1 4 2 1 3 1 1 4 4 15 15 65 65
+ 1 1 4 2 1 3 1 1 4 4 15 15 67 67
+ 1 1 4 2 1 3 1 1 4 4 15 15 69 69
+ 1 1 4 2 1 3 1 1 4 4 15 15 71 71
+ 1 1 4 2 1 3 1 1 4 4 17 17 63 63
+ 1 1 4 2 1 3 1 1 4 4 17 17 65 65
+ 1 1 4 2 1 3 1 1 4 4 17 17 67 67
+ 1 1 4 2 1 3 1 1 4 4 17 17 69 69
+ 1 1 4 2 1 3 1 1 4 4 17 17 71 71
+ 1 1 4 2 1 3 1 1 4 4 19 19 63 63
+ 1 1 4 2 1 3 1 1 4 4 19 19 65 65
+ 1 1 4 2 1 3 1 1 4 4 19 19 67 67
+ 1 1 4 2 1 3 1 1 4 4 19 19 69 69
+ 1 1 4 2 1 3 1 1 4 4 19 19 71 71
+ 1 1 4 2 1 3 1 1 5 5 15 15 63 63
+ 1 1 4 2 1 3 1 1 5 5 15 15 65 65
+ 1 1 4 2 1 3 1 1 5 5 15 15 67 67
+ 1 1 4 2 1 3 1 1 5 5 15 15 69 69
+ 1 1 4 2 1 3 1 1 5 5 15 15 71 71
+ 1 1 4 2 1 3 1 1 5 5 17 17 63 63
+ 1 1 4 2 1 3 1 1 5 5 17 17 65 65
+ 1 1 4 2 1 3 1 1 5 5 17 17 67 67
+ 1 1 4 2 1 3 1 1 5 5 17 17 69 69
+ 1 1 4 2 1 3 1 1 5 5 17 17 71 71
+ 1 1 4 2 1 3 1 1 5 5 19 19 63 63
+ 1 1 4 2 1 3 1 1 5 5 19 19 65 65
+ 1 1 4 2 1 3 1 1 5 5 19 19 67 67
+ 1 1 4 2 1 3 1 1 5 5 19 19 69 69
+ 1 1 4 2 1 3 1 1 5 5 19 19 71 71
+ 1 1 4 2 1 3 1 1 6 6 15 15 63 63
+ 1 1 4 2 1 3 1 1 6 6 15 15 65 65
+ 1 1 4 2 1 3 1 1 6 6 15 15 67 67
+ 1 1 4 2 1 3 1 1 6 6 15 15 69 69
+ 1 1 4 2 1 3 1 1 6 6 15 15 71 71
+ 1 1 4 2 1 3 1 1 6 6 17 17 63 63
+ 1 1 4 2 1 3 1 1 6 6 17 17 65 65
+ 1 1 4 2 1 3 1 1 6 6 17 17 67 67
+ 1 1 4 2 1 3 1 1 6 6 17 17 69 69
+ 1 1 4 2 1 3 1 1 6 6 17 17 71 71
+ 1 1 4 2 1 3 1 1 6 6 19 19 63 63
+ 1 1 4 2 1 3 1 1 6 6 19 19 65 65
+ 1 1 4 2 1 3 1 1 6 6 19 19 67 67
+ 1 1 4 2 1 3 1 1 6 6 19 19 69 69
+ 1 1 4 2 1 3 1 1 6 6 19 19 71 71
+ 1 1 4 2 1 3 2 2 4 4 15 15 63 63
+ 1 1 4 2 1 3 2 2 4 4 15 15 65 65
+ 1 1 4 2 1 3 2 2 4 4 15 15 67 67
+ 1 1 4 2 1 3 2 2 4 4 15 15 69 69
+ 1 1 4 2 1 3 2 2 4 4 15 15 71 71
+ 1 1 4 2 1 3 2 2 4 4 17 17 63 63
+ 1 1 4 2 1 3 2 2 4 4 17 17 65 65
+ 1 1 4 2 1 3 2 2 4 4 17 17 67 67
+ 1 1 4 2 1 3 2 2 4 4 17 17 69 69
+ 1 1 4 2 1 3 2 2 4 4 17 17 71 71
+ 1 1 4 2 1 3 2 2 4 4 19 19 63 63
+ 1 1 4 2 1 3 2 2 4 4 19 19 65 65
+ 1 1 4 2 1 3 2 2 4 4 19 19 67 67
+ 1 1 4 2 1 3 2 2 4 4 19 19 69 69
+ 1 1 4 2 1 3 2 2 4 4 19 19 71 71
+ 1 1 4 2 1 3 2 2 5 5 15 15 63 63
+ 1 1 4 2 1 3 2 2 5 5 15 15 65 65
+ 1 1 4 2 1 3 2 2 5 5 15 15 67 67
+ 1 1 4 2 1 3 2 2 5 5 15 15 69 69
+ 1 1 4 2 1 3 2 2 5 5 15 15 71 71
+ 1 1 4 2 1 3 2 2 5 5 17 17 63 63
+ 1 1 4 2 1 3 2 2 5 5 17 17 65 65
+ 1 1 4 2 1 3 2 2 5 5 17 17 67 67
+ 1 1 4 2 1 3 2 2 5 5 17 17 69 69
+ 1 1 4 2 1 3 2 2 5 5 17 17 71 71
+ 1 1 4 2 1 3 2 2 5 5 19 19 63 63
+ 1 1 4 2 1 3 2 2 5 5 19 19 65 65
+ 1 1 4 2 1 3 2 2 5 5 19 19 67 67
+ 1 1 4 2 1 3 2 2 5 5 19 19 69 69
+ 1 1 4 2 1 3 2 2 5 5 19 19 71 71
+ 1 1 4 2 1 3 2 2 6 6 15 15 63 63
+ 1 1 4 2 1 3 2 2 6 6 15 15 65 65
+ 1 1 4 2 1 3 2 2 6 6 15 15 67 67
+ 1 1 4 2 1 3 2 2 6 6 15 15 69 69
+ 1 1 4 2 1 3 2 2 6 6 15 15 71 71
+ 1 1 4 2 1 3 2 2 6 6 17 17 63 63
+ 1 1 4 2 1 3 2 2 6 6 17 17 65 65
+ 1 1 4 2 1 3 2 2 6 6 17 17 67 67
+ 1 1 4 2 1 3 2 2 6 6 17 17 69 69
+ 1 1 4 2 1 3 2 2 6 6 17 17 71 71
+ 1 1 4 2 1 3 2 2 6 6 19 19 63 63
+ 1 1 4 2 1 3 2 2 6 6 19 19 65 65
+ 1 1 4 2 1 3 2 2 6 6 19 19 67 67
+ 1 1 4 2 1 3 2 2 6 6 19 19 69 69
+ 1 1 4 2 1 3 2 2 6 6 19 19 71 71
+ 1 1 4 2 2 6 1 1 4 4 15 15 63 63
+ 1 1 4 2 2 6 1 1 4 4 15 15 65 65
+ 1 1 4 2 2 6 1 1 4 4 15 15 67 67
+ 1 1 4 2 2 6 1 1 4 4 15 15 69 69
+ 1 1 4 2 2 6 1 1 4 4 15 15 71 71
+ 1 1 4 2 2 6 1 1 4 4 17 17 63 63
+ 1 1 4 2 2 6 1 1 4 4 17 17 65 65
+ 1 1 4 2 2 6 1 1 4 4 17 17 67 67
+ 1 1 4 2 2 6 1 1 4 4 17 17 69 69
+ 1 1 4 2 2 6 1 1 4 4 17 17 71 71
+ 1 1 4 2 2 6 1 1 4 4 19 19 63 63
+ 1 1 4 2 2 6 1 1 4 4 19 19 65 65
+ 1 1 4 2 2 6 1 1 4 4 19 19 67 67
+ 1 1 4 2 2 6 1 1 4 4 19 19 69 69
+ 1 1 4 2 2 6 1 1 4 4 19 19 71 71
+ 1 1 4 2 2 6 1 1 5 5 15 15 63 63
+ 1 1 4 2 2 6 1 1 5 5 15 15 65 65
+ 1 1 4 2 2 6 1 1 5 5 15 15 67 67
+ 1 1 4 2 2 6 1 1 5 5 15 15 69 69
+ 1 1 4 2 2 6 1 1 5 5 15 15 71 71
+ 1 1 4 2 2 6 1 1 5 5 17 17 63 63
+ 1 1 4 2 2 6 1 1 5 5 17 17 65 65
+ 1 1 4 2 2 6 1 1 5 5 17 17 67 67
+ 1 1 4 2 2 6 1 1 5 5 17 17 69 69
+ 1 1 4 2 2 6 1 1 5 5 17 17 71 71
+ 1 1 4 2 2 6 1 1 5 5 19 19 63 63
+ 1 1 4 2 2 6 1 1 5 5 19 19 65 65
+ 1 1 4 2 2 6 1 1 5 5 19 19 67 67
+ 1 1 4 2 2 6 1 1 5 5 19 19 69 69
+ 1 1 4 2 2 6 1 1 5 5 19 19 71 71
+ 1 1 4 2 2 6 1 1 6 6 15 15 63 63
+ 1 1 4 2 2 6 1 1 6 6 15 15 65 65
+ 1 1 4 2 2 6 1 1 6 6 15 15 67 67
+ 1 1 4 2 2 6 1 1 6 6 15 15 69 69
+ 1 1 4 2 2 6 1 1 6 6 15 15 71 71
+ 1 1 4 2 2 6 1 1 6 6 17 17 63 63
+ 1 1 4 2 2 6 1 1 6 6 17 17 65 65
+ 1 1 4 2 2 6 1 1 6 6 17 17 67 67
+ 1 1 4 2 2 6 1 1 6 6 17 17 69 69
+ 1 1 4 2 2 6 1 1 6 6 17 17 71 71
+ 1 1 4 2 2 6 1 1 6 6 19 19 63 63
+ 1 1 4 2 2 6 1 1 6 6 19 19 65 65
+ 1 1 4 2 2 6 1 1 6 6 19 19 67 67
+ 1 1 4 2 2 6 1 1 6 6 19 19 69 69
+ 1 1 4 2 2 6 1 1 6 6 19 19 71 71
+ 1 1 4 2 2 6 2 2 4 4 15 15 63 63
+ 1 1 4 2 2 6 2 2 4 4 15 15 65 65
+ 1 1 4 2 2 6 2 2 4 4 15 15 67 67
+ 1 1 4 2 2 6 2 2 4 4 15 15 69 69
+ 1 1 4 2 2 6 2 2 4 4 15 15 71 71
+ 1 1 4 2 2 6 2 2 4 4 17 17 63 63
+ 1 1 4 2 2 6 2 2 4 4 17 17 65 65
+ 1 1 4 2 2 6 2 2 4 4 17 17 67 67
+ 1 1 4 2 2 6 2 2 4 4 17 17 69 69
+ 1 1 4 2 2 6 2 2 4 4 17 17 71 71
+ 1 1 4 2 2 6 2 2 4 4 19 19 63 63
+ 1 1 4 2 2 6 2 2 4 4 19 19 65 65
+ 1 1 4 2 2 6 2 2 4 4 19 19 67 67
+ 1 1 4 2 2 6 2 2 4 4 19 19 69 69
+ 1 1 4 2 2 6 2 2 4 4 19 19 71 71
+ 1 1 4 2 2 6 2 2 5 5 15 15 63 63
+ 1 1 4 2 2 6 2 2 5 5 15 15 65 65
+ 1 1 4 2 2 6 2 2 5 5 15 15 67 67
+ 1 1 4 2 2 6 2 2 5 5 15 15 69 69
+ 1 1 4 2 2 6 2 2 5 5 15 15 71 71
+ 1 1 4 2 2 6 2 2 5 5 17 17 63 63
+ 1 1 4 2 2 6 2 2 5 5 17 17 65 65
+ 1 1 4 2 2 6 2 2 5 5 17 17 67 67
+ 1 1 4 2 2 6 2 2 5 5 17 17 69 69
+ 1 1 4 2 2 6 2 2 5 5 17 17 71 71
+ 1 1 4 2 2 6 2 2 5 5 19 19 63 63
+ 1 1 4 2 2 6 2 2 5 5 19 19 65 65
+ 1 1 4 2 2 6 2 2 5 5 19 19 67 67
+ 1 1 4 2 2 6 2 2 5 5 19 19 69 69
+ 1 1 4 2 2 6 2 2 5 5 19 19 71 71
+ 1 1 4 2 2 6 2 2 6 6 15 15 63 63
+ 1 1 4 2 2 6 2 2 6 6 15 15 65 65
+ 1 1 4 2 2 6 2 2 6 6 15 15 67 67
+ 1 1 4 2 2 6 2 2 6 6 15 15 69 69
+ 1 1 4 2 2 6 2 2 6 6 15 15 71 71
+ 1 1 4 2 2 6 2 2 6 6 17 17 63 63
+ 1 1 4 2 2 6 2 2 6 6 17 17 65 65
+ 1 1 4 2 2 6 2 2 6 6 17 17 67 67
+ 1 1 4 2 2 6 2 2 6 6 17 17 69 69
+ 1 1 4 2 2 6 2 2 6 6 17 17 71 71
+ 1 1 4 2 2 6 2 2 6 6 19 19 63 63
+ 1 1 4 2 2 6 2 2 6 6 19 19 65 65
+ 1 1 4 2 2 6 2 2 6 6 19 19 67 67
+ 1 1 4 2 2 6 2 2 6 6 19 19 69 69
+ 1 1 4 2 2 6 2 2 6 6 19 19 71 71
+ 2 2 2 1 1 3 1 1 4 4 15 15 63 63
+ 2 2 2 1 1 3 1 1 4 4 15 15 65 65
+ 2 2 2 1 1 3 1 1 4 4 15 15 67 67
+ 2 2 2 1 1 3 1 1 4 4 15 15 69 69
+ 2 2 2 1 1 3 1 1 4 4 15 15 71 71
+ 2 2 2 1 1 3 1 1 4 4 17 17 63 63
+ 2 2 2 1 1 3 1 1 4 4 17 17 65 65
+ 2 2 2 1 1 3 1 1 4 4 17 17 67 67
+ 2 2 2 1 1 3 1 1 4 4 17 17 69 69
+ 2 2 2 1 1 3 1 1 4 4 17 17 71 71
+ 2 2 2 1 1 3 1 1 4 4 19 19 63 63
+ 2 2 2 1 1 3 1 1 4 4 19 19 65 65
+ 2 2 2 1 1 3 1 1 4 4 19 19 67 67
+ 2 2 2 1 1 3 1 1 4 4 19 19 69 69
+ 2 2 2 1 1 3 1 1 4 4 19 19 71 71
+ 2 2 2 1 1 3 1 1 5 5 15 15 63 63
+ 2 2 2 1 1 3 1 1 5 5 15 15 65 65
+ 2 2 2 1 1 3 1 1 5 5 15 15 67 67
+ 2 2 2 1 1 3 1 1 5 5 15 15 69 69
+ 2 2 2 1 1 3 1 1 5 5 15 15 71 71
+ 2 2 2 1 1 3 1 1 5 5 17 17 63 63
+ 2 2 2 1 1 3 1 1 5 5 17 17 65 65
+ 2 2 2 1 1 3 1 1 5 5 17 17 67 67
+ 2 2 2 1 1 3 1 1 5 5 17 17 69 69
+ 2 2 2 1 1 3 1 1 5 5 17 17 71 71
+ 2 2 2 1 1 3 1 1 5 5 19 19 63 63
+ 2 2 2 1 1 3 1 1 5 5 19 19 65 65
+ 2 2 2 1 1 3 1 1 5 5 19 19 67 67
+ 2 2 2 1 1 3 1 1 5 5 19 19 69 69
+ 2 2 2 1 1 3 1 1 5 5 19 19 71 71
+ 2 2 2 1 1 3 1 1 6 6 15 15 63 63
+ 2 2 2 1 1 3 1 1 6 6 15 15 65 65
+ 2 2 2 1 1 3 1 1 6 6 15 15 67 67
+ 2 2 2 1 1 3 1 1 6 6 15 15 69 69
+ 2 2 2 1 1 3 1 1 6 6 15 15 71 71
+ 2 2 2 1 1 3 1 1 6 6 17 17 63 63
+ 2 2 2 1 1 3 1 1 6 6 17 17 65 65
+ 2 2 2 1 1 3 1 1 6 6 17 17 67 67
+ 2 2 2 1 1 3 1 1 6 6 17 17 69 69
+ 2 2 2 1 1 3 1 1 6 6 17 17 71 71
+ 2 2 2 1 1 3 1 1 6 6 19 19 63 63
+ 2 2 2 1 1 3 1 1 6 6 19 19 65 65
+ 2 2 2 1 1 3 1 1 6 6 19 19 67 67
+ 2 2 2 1 1 3 1 1 6 6 19 19 69 69
+ 2 2 2 1 1 3 1 1 6 6 19 19 71 71
+ 2 2 2 1 1 3 2 2 4 4 15 15 63 63
+ 2 2 2 1 1 3 2 2 4 4 15 15 65 65
+ 2 2 2 1 1 3 2 2 4 4 15 15 67 67
+ 2 2 2 1 1 3 2 2 4 4 15 15 69 69
+ 2 2 2 1 1 3 2 2 4 4 15 15 71 71
+ 2 2 2 1 1 3 2 2 4 4 17 17 63 63
+ 2 2 2 1 1 3 2 2 4 4 17 17 65 65
+ 2 2 2 1 1 3 2 2 4 4 17 17 67 67
+ 2 2 2 1 1 3 2 2 4 4 17 17 69 69
+ 2 2 2 1 1 3 2 2 4 4 17 17 71 71
+ 2 2 2 1 1 3 2 2 4 4 19 19 63 63
+ 2 2 2 1 1 3 2 2 4 4 19 19 65 65
+ 2 2 2 1 1 3 2 2 4 4 19 19 67 67
+ 2 2 2 1 1 3 2 2 4 4 19 19 69 69
+ 2 2 2 1 1 3 2 2 4 4 19 19 71 71
+ 2 2 2 1 1 3 2 2 5 5 15 15 63 63
+ 2 2 2 1 1 3 2 2 5 5 15 15 65 65
+ 2 2 2 1 1 3 2 2 5 5 15 15 67 67
+ 2 2 2 1 1 3 2 2 5 5 15 15 69 69
+ 2 2 2 1 1 3 2 2 5 5 15 15 71 71
+ 2 2 2 1 1 3 2 2 5 5 17 17 63 63
+ 2 2 2 1 1 3 2 2 5 5 17 17 65 65
+ 2 2 2 1 1 3 2 2 5 5 17 17 67 67
+ 2 2 2 1 1 3 2 2 5 5 17 17 69 69
+ 2 2 2 1 1 3 2 2 5 5 17 17 71 71
+ 2 2 2 1 1 3 2 2 5 5 19 19 63 63
+ 2 2 2 1 1 3 2 2 5 5 19 19 65 65
+ 2 2 2 1 1 3 2 2 5 5 19 19 67 67
+ 2 2 2 1 1 3 2 2 5 5 19 19 69 69
+ 2 2 2 1 1 3 2 2 5 5 19 19 71 71
+ 2 2 2 1 1 3 2 2 6 6 15 15 63 63
+ 2 2 2 1 1 3 2 2 6 6 15 15 65 65
+ 2 2 2 1 1 3 2 2 6 6 15 15 67 67
+ 2 2 2 1 1 3 2 2 6 6 15 15 69 69
+ 2 2 2 1 1 3 2 2 6 6 15 15 71 71
+ 2 2 2 1 1 3 2 2 6 6 17 17 63 63
+ 2 2 2 1 1 3 2 2 6 6 17 17 65 65
+ 2 2 2 1 1 3 2 2 6 6 17 17 67 67
+ 2 2 2 1 1 3 2 2 6 6 17 17 69 69
+ 2 2 2 1 1 3 2 2 6 6 17 17 71 71
+ 2 2 2 1 1 3 2 2 6 6 19 19 63 63
+ 2 2 2 1 1 3 2 2 6 6 19 19 65 65
+ 2 2 2 1 1 3 2 2 6 6 19 19 67 67
+ 2 2 2 1 1 3 2 2 6 6 19 19 69 69
+ 2 2 2 1 1 3 2 2 6 6 19 19 71 71
+ 2 2 2 1 2 6 1 1 4 4 15 15 63 63
+ 2 2 2 1 2 6 1 1 4 4 15 15 65 65
+ 2 2 2 1 2 6 1 1 4 4 15 15 67 67
+ 2 2 2 1 2 6 1 1 4 4 15 15 69 69
+ 2 2 2 1 2 6 1 1 4 4 15 15 71 71
+ 2 2 2 1 2 6 1 1 4 4 17 17 63 63
+ 2 2 2 1 2 6 1 1 4 4 17 17 65 65
+ 2 2 2 1 2 6 1 1 4 4 17 17 67 67
+ 2 2 2 1 2 6 1 1 4 4 17 17 69 69
+ 2 2 2 1 2 6 1 1 4 4 17 17 71 71
+ 2 2 2 1 2 6 1 1 4 4 19 19 63 63
+ 2 2 2 1 2 6 1 1 4 4 19 19 65 65
+ 2 2 2 1 2 6 1 1 4 4 19 19 67 67
+ 2 2 2 1 2 6 1 1 4 4 19 19 69 69
+ 2 2 2 1 2 6 1 1 4 4 19 19 71 71
+ 2 2 2 1 2 6 1 1 5 5 15 15 63 63
+ 2 2 2 1 2 6 1 1 5 5 15 15 65 65
+ 2 2 2 1 2 6 1 1 5 5 15 15 67 67
+ 2 2 2 1 2 6 1 1 5 5 15 15 69 69
+ 2 2 2 1 2 6 1 1 5 5 15 15 71 71
+ 2 2 2 1 2 6 1 1 5 5 17 17 63 63
+ 2 2 2 1 2 6 1 1 5 5 17 17 65 65
+ 2 2 2 1 2 6 1 1 5 5 17 17 67 67
+ 2 2 2 1 2 6 1 1 5 5 17 17 69 69
+ 2 2 2 1 2 6 1 1 5 5 17 17 71 71
+ 2 2 2 1 2 6 1 1 5 5 19 19 63 63
+ 2 2 2 1 2 6 1 1 5 5 19 19 65 65
+ 2 2 2 1 2 6 1 1 5 5 19 19 67 67
+ 2 2 2 1 2 6 1 1 5 5 19 19 69 69
+ 2 2 2 1 2 6 1 1 5 5 19 19 71 71
+ 2 2 2 1 2 6 1 1 6 6 15 15 63 63
+ 2 2 2 1 2 6 1 1 6 6 15 15 65 65
+ 2 2 2 1 2 6 1 1 6 6 15 15 67 67
+ 2 2 2 1 2 6 1 1 6 6 15 15 69 69
+ 2 2 2 1 2 6 1 1 6 6 15 15 71 71
+ 2 2 2 1 2 6 1 1 6 6 17 17 63 63
+ 2 2 2 1 2 6 1 1 6 6 17 17 65 65
+ 2 2 2 1 2 6 1 1 6 6 17 17 67 67
+ 2 2 2 1 2 6 1 1 6 6 17 17 69 69
+ 2 2 2 1 2 6 1 1 6 6 17 17 71 71
+ 2 2 2 1 2 6 1 1 6 6 19 19 63 63
+ 2 2 2 1 2 6 1 1 6 6 19 19 65 65
+ 2 2 2 1 2 6 1 1 6 6 19 19 67 67
+ 2 2 2 1 2 6 1 1 6 6 19 19 69 69
+ 2 2 2 1 2 6 1 1 6 6 19 19 71 71
+ 2 2 2 1 2 6 2 2 4 4 15 15 63 63
+ 2 2 2 1 2 6 2 2 4 4 15 15 65 65
+ 2 2 2 1 2 6 2 2 4 4 15 15 67 67
+ 2 2 2 1 2 6 2 2 4 4 15 15 69 69
+ 2 2 2 1 2 6 2 2 4 4 15 15 71 71
+ 2 2 2 1 2 6 2 2 4 4 17 17 63 63
+ 2 2 2 1 2 6 2 2 4 4 17 17 65 65
+ 2 2 2 1 2 6 2 2 4 4 17 17 67 67
+ 2 2 2 1 2 6 2 2 4 4 17 17 69 69
+ 2 2 2 1 2 6 2 2 4 4 17 17 71 71
+ 2 2 2 1 2 6 2 2 4 4 19 19 63 63
+ 2 2 2 1 2 6 2 2 4 4 19 19 65 65
+ 2 2 2 1 2 6 2 2 4 4 19 19 67 67
+ 2 2 2 1 2 6 2 2 4 4 19 19 69 69
+ 2 2 2 1 2 6 2 2 4 4 19 19 71 71
+ 2 2 2 1 2 6 2 2 5 5 15 15 63 63
+ 2 2 2 1 2 6 2 2 5 5 15 15 65 65
+ 2 2 2 1 2 6 2 2 5 5 15 15 67 67
+ 2 2 2 1 2 6 2 2 5 5 15 15 69 69
+ 2 2 2 1 2 6 2 2 5 5 15 15 71 71
+ 2 2 2 1 2 6 2 2 5 5 17 17 63 63
+ 2 2 2 1 2 6 2 2 5 5 17 17 65 65
+ 2 2 2 1 2 6 2 2 5 5 17 17 67 67
+ 2 2 2 1 2 6 2 2 5 5 17 17 69 69
+ 2 2 2 1 2 6 2 2 5 5 17 17 71 71
+ 2 2 2 1 2 6 2 2 5 5 19 19 63 63
+ 2 2 2 1 2 6 2 2 5 5 19 19 65 65
+ 2 2 2 1 2 6 2 2 5 5 19 19 67 67
+ 2 2 2 1 2 6 2 2 5 5 19 19 69 69
+ 2 2 2 1 2 6 2 2 5 5 19 19 71 71
+ 2 2 2 1 2 6 2 2 6 6 15 15 63 63
+ 2 2 2 1 2 6 2 2 6 6 15 15 65 65
+ 2 2 2 1 2 6 2 2 6 6 15 15 67 67
+ 2 2 2 1 2 6 2 2 6 6 15 15 69 69
+ 2 2 2 1 2 6 2 2 6 6 15 15 71 71
+ 2 2 2 1 2 6 2 2 6 6 17 17 63 63
+ 2 2 2 1 2 6 2 2 6 6 17 17 65 65
+ 2 2 2 1 2 6 2 2 6 6 17 17 67 67
+ 2 2 2 1 2 6 2 2 6 6 17 17 69 69
+ 2 2 2 1 2 6 2 2 6 6 17 17 71 71
+ 2 2 2 1 2 6 2 2 6 6 19 19 63 63
+ 2 2 2 1 2 6 2 2 6 6 19 19 65 65
+ 2 2 2 1 2 6 2 2 6 6 19 19 67 67
+ 2 2 2 1 2 6 2 2 6 6 19 19 69 69
+ 2 2 2 1 2 6 2 2 6 6 19 19 71 71
+ 2 2 3 2 1 3 1 1 4 4 15 15 63 63
+ 2 2 3 2 1 3 1 1 4 4 15 15 65 65
+ 2 2 3 2 1 3 1 1 4 4 15 15 67 67
+ 2 2 3 2 1 3 1 1 4 4 15 15 69 69
+ 2 2 3 2 1 3 1 1 4 4 15 15 71 71
+ 2 2 3 2 1 3 1 1 4 4 17 17 63 63
+ 2 2 3 2 1 3 1 1 4 4 17 17 65 65
+ 2 2 3 2 1 3 1 1 4 4 17 17 67 67
+ 2 2 3 2 1 3 1 1 4 4 17 17 69 69
+ 2 2 3 2 1 3 1 1 4 4 17 17 71 71
+ 2 2 3 2 1 3 1 1 4 4 19 19 63 63
+ 2 2 3 2 1 3 1 1 4 4 19 19 65 65
+ 2 2 3 2 1 3 1 1 4 4 19 19 67 67
+ 2 2 3 2 1 3 1 1 4 4 19 19 69 69
+ 2 2 3 2 1 3 1 1 4 4 19 19 71 71
+ 2 2 3 2 1 3 1 1 5 5 15 15 63 63
+ 2 2 3 2 1 3 1 1 5 5 15 15 65 65
+ 2 2 3 2 1 3 1 1 5 5 15 15 67 67
+ 2 2 3 2 1 3 1 1 5 5 15 15 69 69
+ 2 2 3 2 1 3 1 1 5 5 15 15 71 71
+ 2 2 3 2 1 3 1 1 5 5 17 17 63 63
+ 2 2 3 2 1 3 1 1 5 5 17 17 65 65
+ 2 2 3 2 1 3 1 1 5 5 17 17 67 67
+ 2 2 3 2 1 3 1 1 5 5 17 17 69 69
+ 2 2 3 2 1 3 1 1 5 5 17 17 71 71
+ 2 2 3 2 1 3 1 1 5 5 19 19 63 63
+ 2 2 3 2 1 3 1 1 5 5 19 19 65 65
+ 2 2 3 2 1 3 1 1 5 5 19 19 67 67
+ 2 2 3 2 1 3 1 1 5 5 19 19 69 69
+ 2 2 3 2 1 3 1 1 5 5 19 19 71 71
+ 2 2 3 2 1 3 1 1 6 6 15 15 63 63
+ 2 2 3 2 1 3 1 1 6 6 15 15 65 65
+ 2 2 3 2 1 3 1 1 6 6 15 15 67 67
+ 2 2 3 2 1 3 1 1 6 6 15 15 69 69
+ 2 2 3 2 1 3 1 1 6 6 15 15 71 71
+ 2 2 3 2 1 3 1 1 6 6 17 17 63 63
+ 2 2 3 2 1 3 1 1 6 6 17 17 65 65
+ 2 2 3 2 1 3 1 1 6 6 17 17 67 67
+ 2 2 3 2 1 3 1 1 6 6 17 17 69 69
+ 2 2 3 2 1 3 1 1 6 6 17 17 71 71
+ 2 2 3 2 1 3 1 1 6 6 19 19 63 63
+ 2 2 3 2 1 3 1 1 6 6 19 19 65 65
+ 2 2 3 2 1 3 1 1 6 6 19 19 67 67
+ 2 2 3 2 1 3 1 1 6 6 19 19 69 69
+ 2 2 3 2 1 3 1 1 6 6 19 19 71 71
+ 2 2 3 2 1 3 2 2 4 4 15 15 63 63
+ 2 2 3 2 1 3 2 2 4 4 15 15 65 65
+ 2 2 3 2 1 3 2 2 4 4 15 15 67 67
+ 2 2 3 2 1 3 2 2 4 4 15 15 69 69
+ 2 2 3 2 1 3 2 2 4 4 15 15 71 71
+ 2 2 3 2 1 3 2 2 4 4 17 17 63 63
+ 2 2 3 2 1 3 2 2 4 4 17 17 65 65
+ 2 2 3 2 1 3 2 2 4 4 17 17 67 67
+ 2 2 3 2 1 3 2 2 4 4 17 17 69 69
+ 2 2 3 2 1 3 2 2 4 4 17 17 71 71
+ 2 2 3 2 1 3 2 2 4 4 19 19 63 63
+ 2 2 3 2 1 3 2 2 4 4 19 19 65 65
+ 2 2 3 2 1 3 2 2 4 4 19 19 67 67
+ 2 2 3 2 1 3 2 2 4 4 19 19 69 69
+ 2 2 3 2 1 3 2 2 4 4 19 19 71 71
+ 2 2 3 2 1 3 2 2 5 5 15 15 63 63
+ 2 2 3 2 1 3 2 2 5 5 15 15 65 65
+ 2 2 3 2 1 3 2 2 5 5 15 15 67 67
+ 2 2 3 2 1 3 2 2 5 5 15 15 69 69
+ 2 2 3 2 1 3 2 2 5 5 15 15 71 71
+ 2 2 3 2 1 3 2 2 5 5 17 17 63 63
+ 2 2 3 2 1 3 2 2 5 5 17 17 65 65
+ 2 2 3 2 1 3 2 2 5 5 17 17 67 67
+ 2 2 3 2 1 3 2 2 5 5 17 17 69 69
+ 2 2 3 2 1 3 2 2 5 5 17 17 71 71
+ 2 2 3 2 1 3 2 2 5 5 19 19 63 63
+ 2 2 3 2 1 3 2 2 5 5 19 19 65 65
+ 2 2 3 2 1 3 2 2 5 5 19 19 67 67
+ 2 2 3 2 1 3 2 2 5 5 19 19 69 69
+ 2 2 3 2 1 3 2 2 5 5 19 19 71 71
+ 2 2 3 2 1 3 2 2 6 6 15 15 63 63
+ 2 2 3 2 1 3 2 2 6 6 15 15 65 65
+ 2 2 3 2 1 3 2 2 6 6 15 15 67 67
+ 2 2 3 2 1 3 2 2 6 6 15 15 69 69
+ 2 2 3 2 1 3 2 2 6 6 15 15 71 71
+ 2 2 3 2 1 3 2 2 6 6 17 17 63 63
+ 2 2 3 2 1 3 2 2 6 6 17 17 65 65
+ 2 2 3 2 1 3 2 2 6 6 17 17 67 67
+ 2 2 3 2 1 3 2 2 6 6 17 17 69 69
+ 2 2 3 2 1 3 2 2 6 6 17 17 71 71
+ 2 2 3 2 1 3 2 2 6 6 19 19 63 63
+ 2 2 3 2 1 3 2 2 6 6 19 19 65 65
+ 2 2 3 2 1 3 2 2 6 6 19 19 67 67
+ 2 2 3 2 1 3 2 2 6 6 19 19 69 69
+ 2 2 3 2 1 3 2 2 6 6 19 19 71 71
+ 2 2 3 2 2 6 1 1 4 4 15 15 63 63
+ 2 2 3 2 2 6 1 1 4 4 15 15 65 65
+ 2 2 3 2 2 6 1 1 4 4 15 15 67 67
+ 2 2 3 2 2 6 1 1 4 4 15 15 69 69
+ 2 2 3 2 2 6 1 1 4 4 15 15 71 71
+ 2 2 3 2 2 6 1 1 4 4 17 17 63 63
+ 2 2 3 2 2 6 1 1 4 4 17 17 65 65
+ 2 2 3 2 2 6 1 1 4 4 17 17 67 67
+ 2 2 3 2 2 6 1 1 4 4 17 17 69 69
+ 2 2 3 2 2 6 1 1 4 4 17 17 71 71
+ 2 2 3 2 2 6 1 1 4 4 19 19 63 63
+ 2 2 3 2 2 6 1 1 4 4 19 19 65 65
+ 2 2 3 2 2 6 1 1 4 4 19 19 67 67
+ 2 2 3 2 2 6 1 1 4 4 19 19 69 69
+ 2 2 3 2 2 6 1 1 4 4 19 19 71 71
+ 2 2 3 2 2 6 1 1 5 5 15 15 63 63
+ 2 2 3 2 2 6 1 1 5 5 15 15 65 65
+ 2 2 3 2 2 6 1 1 5 5 15 15 67 67
+ 2 2 3 2 2 6 1 1 5 5 15 15 69 69
+ 2 2 3 2 2 6 1 1 5 5 15 15 71 71
+ 2 2 3 2 2 6 1 1 5 5 17 17 63 63
+ 2 2 3 2 2 6 1 1 5 5 17 17 65 65
+ 2 2 3 2 2 6 1 1 5 5 17 17 67 67
+ 2 2 3 2 2 6 1 1 5 5 17 17 69 69
+ 2 2 3 2 2 6 1 1 5 5 17 17 71 71
+ 2 2 3 2 2 6 1 1 5 5 19 19 63 63
+ 2 2 3 2 2 6 1 1 5 5 19 19 65 65
+ 2 2 3 2 2 6 1 1 5 5 19 19 67 67
+ 2 2 3 2 2 6 1 1 5 5 19 19 69 69
+ 2 2 3 2 2 6 1 1 5 5 19 19 71 71
+ 2 2 3 2 2 6 1 1 6 6 15 15 63 63
+ 2 2 3 2 2 6 1 1 6 6 15 15 65 65
+ 2 2 3 2 2 6 1 1 6 6 15 15 67 67
+ 2 2 3 2 2 6 1 1 6 6 15 15 69 69
+ 2 2 3 2 2 6 1 1 6 6 15 15 71 71
+ 2 2 3 2 2 6 1 1 6 6 17 17 63 63
+ 2 2 3 2 2 6 1 1 6 6 17 17 65 65
+ 2 2 3 2 2 6 1 1 6 6 17 17 67 67
+ 2 2 3 2 2 6 1 1 6 6 17 17 69 69
+ 2 2 3 2 2 6 1 1 6 6 17 17 71 71
+ 2 2 3 2 2 6 1 1 6 6 19 19 63 63
+ 2 2 3 2 2 6 1 1 6 6 19 19 65 65
+ 2 2 3 2 2 6 1 1 6 6 19 19 67 67
+ 2 2 3 2 2 6 1 1 6 6 19 19 69 69
+ 2 2 3 2 2 6 1 1 6 6 19 19 71 71
+ 2 2 3 2 2 6 2 2 4 4 15 15 63 63
+ 2 2 3 2 2 6 2 2 4 4 15 15 65 65
+ 2 2 3 2 2 6 2 2 4 4 15 15 67 67
+ 2 2 3 2 2 6 2 2 4 4 15 15 69 69
+ 2 2 3 2 2 6 2 2 4 4 15 15 71 71
+ 2 2 3 2 2 6 2 2 4 4 17 17 63 63
+ 2 2 3 2 2 6 2 2 4 4 17 17 65 65
+ 2 2 3 2 2 6 2 2 4 4 17 17 67 67
+ 2 2 3 2 2 6 2 2 4 4 17 17 69 69
+ 2 2 3 2 2 6 2 2 4 4 17 17 71 71
+ 2 2 3 2 2 6 2 2 4 4 19 19 63 63
+ 2 2 3 2 2 6 2 2 4 4 19 19 65 65
+ 2 2 3 2 2 6 2 2 4 4 19 19 67 67
+ 2 2 3 2 2 6 2 2 4 4 19 19 69 69
+ 2 2 3 2 2 6 2 2 4 4 19 19 71 71
+ 2 2 3 2 2 6 2 2 5 5 15 15 63 63
+ 2 2 3 2 2 6 2 2 5 5 15 15 65 65
+ 2 2 3 2 2 6 2 2 5 5 15 15 67 67
+ 2 2 3 2 2 6 2 2 5 5 15 15 69 69
+ 2 2 3 2 2 6 2 2 5 5 15 15 71 71
+ 2 2 3 2 2 6 2 2 5 5 17 17 63 63
+ 2 2 3 2 2 6 2 2 5 5 17 17 65 65
+ 2 2 3 2 2 6 2 2 5 5 17 17 67 67
+ 2 2 3 2 2 6 2 2 5 5 17 17 69 69
+ 2 2 3 2 2 6 2 2 5 5 17 17 71 71
+ 2 2 3 2 2 6 2 2 5 5 19 19 63 63
+ 2 2 3 2 2 6 2 2 5 5 19 19 65 65
+ 2 2 3 2 2 6 2 2 5 5 19 19 67 67
+ 2 2 3 2 2 6 2 2 5 5 19 19 69 69
+ 2 2 3 2 2 6 2 2 5 5 19 19 71 71
+ 2 2 3 2 2 6 2 2 6 6 15 15 63 63
+ 2 2 3 2 2 6 2 2 6 6 15 15 65 65
+ 2 2 3 2 2 6 2 2 6 6 15 15 67 67
+ 2 2 3 2 2 6 2 2 6 6 15 15 69 69
+ 2 2 3 2 2 6 2 2 6 6 15 15 71 71
+ 2 2 3 2 2 6 2 2 6 6 17 17 63 63
+ 2 2 3 2 2 6 2 2 6 6 17 17 65 65
+ 2 2 3 2 2 6 2 2 6 6 17 17 67 67
+ 2 2 3 2 2 6 2 2 6 6 17 17 69 69
+ 2 2 3 2 2 6 2 2 6 6 17 17 71 71
+ 2 2 3 2 2 6 2 2 6 6 19 19 63 63
+ 2 2 3 2 2 6 2 2 6 6 19 19 65 65
+ 2 2 3 2 2 6 2 2 6 6 19 19 67 67
+ 2 2 3 2 2 6 2 2 6 6 19 19 69 69
+ 2 2 3 2 2 6 2 2 6 6 19 19 71 71
+ 2 2 4 2 1 3 1 1 4 4 15 15 63 63
+ 2 2 4 2 1 3 1 1 4 4 15 15 65 65
+ 2 2 4 2 1 3 1 1 4 4 15 15 67 67
+ 2 2 4 2 1 3 1 1 4 4 15 15 69 69
+ 2 2 4 2 1 3 1 1 4 4 15 15 71 71
+ 2 2 4 2 1 3 1 1 4 4 17 17 63 63
+ 2 2 4 2 1 3 1 1 4 4 17 17 65 65
+ 2 2 4 2 1 3 1 1 4 4 17 17 67 67
+ 2 2 4 2 1 3 1 1 4 4 17 17 69 69
+ 2 2 4 2 1 3 1 1 4 4 17 17 71 71
+ 2 2 4 2 1 3 1 1 4 4 19 19 63 63
+ 2 2 4 2 1 3 1 1 4 4 19 19 65 65
+ 2 2 4 2 1 3 1 1 4 4 19 19 67 67
+ 2 2 4 2 1 3 1 1 4 4 19 19 69 69
+ 2 2 4 2 1 3 1 1 4 4 19 19 71 71
+ 2 2 4 2 1 3 1 1 5 5 15 15 63 63
+ 2 2 4 2 1 3 1 1 5 5 15 15 65 65
+ 2 2 4 2 1 3 1 1 5 5 15 15 67 67
+ 2 2 4 2 1 3 1 1 5 5 15 15 69 69
+ 2 2 4 2 1 3 1 1 5 5 15 15 71 71
+ 2 2 4 2 1 3 1 1 5 5 17 17 63 63
+ 2 2 4 2 1 3 1 1 5 5 17 17 65 65
+ 2 2 4 2 1 3 1 1 5 5 17 17 67 67
+ 2 2 4 2 1 3 1 1 5 5 17 17 69 69
+ 2 2 4 2 1 3 1 1 5 5 17 17 71 71
+ 2 2 4 2 1 3 1 1 5 5 19 19 63 63
+ 2 2 4 2 1 3 1 1 5 5 19 19 65 65
+ 2 2 4 2 1 3 1 1 5 5 19 19 67 67
+ 2 2 4 2 1 3 1 1 5 5 19 19 69 69
+ 2 2 4 2 1 3 1 1 5 5 19 19 71 71
+ 2 2 4 2 1 3 1 1 6 6 15 15 63 63
+ 2 2 4 2 1 3 1 1 6 6 15 15 65 65
+ 2 2 4 2 1 3 1 1 6 6 15 15 67 67
+ 2 2 4 2 1 3 1 1 6 6 15 15 69 69
+ 2 2 4 2 1 3 1 1 6 6 15 15 71 71
+ 2 2 4 2 1 3 1 1 6 6 17 17 63 63
+ 2 2 4 2 1 3 1 1 6 6 17 17 65 65
+ 2 2 4 2 1 3 1 1 6 6 17 17 67 67
+ 2 2 4 2 1 3 1 1 6 6 17 17 69 69
+ 2 2 4 2 1 3 1 1 6 6 17 17 71 71
+ 2 2 4 2 1 3 1 1 6 6 19 19 63 63
+ 2 2 4 2 1 3 1 1 6 6 19 19 65 65
+ 2 2 4 2 1 3 1 1 6 6 19 19 67 67
+ 2 2 4 2 1 3 1 1 6 6 19 19 69 69
+ 2 2 4 2 1 3 1 1 6 6 19 19 71 71
+ 2 2 4 2 1 3 2 2 4 4 15 15 63 63
+ 2 2 4 2 1 3 2 2 4 4 15 15 65 65
+ 2 2 4 2 1 3 2 2 4 4 15 15 67 67
+ 2 2 4 2 1 3 2 2 4 4 15 15 69 69
+ 2 2 4 2 1 3 2 2 4 4 15 15 71 71
+ 2 2 4 2 1 3 2 2 4 4 17 17 63 63
+ 2 2 4 2 1 3 2 2 4 4 17 17 65 65
+ 2 2 4 2 1 3 2 2 4 4 17 17 67 67
+ 2 2 4 2 1 3 2 2 4 4 17 17 69 69
+ 2 2 4 2 1 3 2 2 4 4 17 17 71 71
+ 2 2 4 2 1 3 2 2 4 4 19 19 63 63
+ 2 2 4 2 1 3 2 2 4 4 19 19 65 65
+ 2 2 4 2 1 3 2 2 4 4 19 19 67 67
+ 2 2 4 2 1 3 2 2 4 4 19 19 69 69
+ 2 2 4 2 1 3 2 2 4 4 19 19 71 71
+ 2 2 4 2 1 3 2 2 5 5 15 15 63 63
+ 2 2 4 2 1 3 2 2 5 5 15 15 65 65
+ 2 2 4 2 1 3 2 2 5 5 15 15 67 67
+ 2 2 4 2 1 3 2 2 5 5 15 15 69 69
+ 2 2 4 2 1 3 2 2 5 5 15 15 71 71
+ 2 2 4 2 1 3 2 2 5 5 17 17 63 63
+ 2 2 4 2 1 3 2 2 5 5 17 17 65 65
+ 2 2 4 2 1 3 2 2 5 5 17 17 67 67
+ 2 2 4 2 1 3 2 2 5 5 17 17 69 69
+ 2 2 4 2 1 3 2 2 5 5 17 17 71 71
+ 2 2 4 2 1 3 2 2 5 5 19 19 63 63
+ 2 2 4 2 1 3 2 2 5 5 19 19 65 65
+ 2 2 4 2 1 3 2 2 5 5 19 19 67 67
+ 2 2 4 2 1 3 2 2 5 5 19 19 69 69
+ 2 2 4 2 1 3 2 2 5 5 19 19 71 71
+ 2 2 4 2 1 3 2 2 6 6 15 15 63 63
+ 2 2 4 2 1 3 2 2 6 6 15 15 65 65
+ 2 2 4 2 1 3 2 2 6 6 15 15 67 67
+ 2 2 4 2 1 3 2 2 6 6 15 15 69 69
+ 2 2 4 2 1 3 2 2 6 6 15 15 71 71
+ 2 2 4 2 1 3 2 2 6 6 17 17 63 63
+ 2 2 4 2 1 3 2 2 6 6 17 17 65 65
+ 2 2 4 2 1 3 2 2 6 6 17 17 67 67
+ 2 2 4 2 1 3 2 2 6 6 17 17 69 69
+ 2 2 4 2 1 3 2 2 6 6 17 17 71 71
+ 2 2 4 2 1 3 2 2 6 6 19 19 63 63
+ 2 2 4 2 1 3 2 2 6 6 19 19 65 65
+ 2 2 4 2 1 3 2 2 6 6 19 19 67 67
+ 2 2 4 2 1 3 2 2 6 6 19 19 69 69
+ 2 2 4 2 1 3 2 2 6 6 19 19 71 71
+ 2 2 4 2 2 6 1 1 4 4 15 15 63 63
+ 2 2 4 2 2 6 1 1 4 4 15 15 65 65
+ 2 2 4 2 2 6 1 1 4 4 15 15 67 67
+ 2 2 4 2 2 6 1 1 4 4 15 15 69 69
+ 2 2 4 2 2 6 1 1 4 4 15 15 71 71
+ 2 2 4 2 2 6 1 1 4 4 17 17 63 63
+ 2 2 4 2 2 6 1 1 4 4 17 17 65 65
+ 2 2 4 2 2 6 1 1 4 4 17 17 67 67
+ 2 2 4 2 2 6 1 1 4 4 17 17 69 69
+ 2 2 4 2 2 6 1 1 4 4 17 17 71 71
+ 2 2 4 2 2 6 1 1 4 4 19 19 63 63
+ 2 2 4 2 2 6 1 1 4 4 19 19 65 65
+ 2 2 4 2 2 6 1 1 4 4 19 19 67 67
+ 2 2 4 2 2 6 1 1 4 4 19 19 69 69
+ 2 2 4 2 2 6 1 1 4 4 19 19 71 71
+ 2 2 4 2 2 6 1 1 5 5 15 15 63 63
+ 2 2 4 2 2 6 1 1 5 5 15 15 65 65
+ 2 2 4 2 2 6 1 1 5 5 15 15 67 67
+ 2 2 4 2 2 6 1 1 5 5 15 15 69 69
+ 2 2 4 2 2 6 1 1 5 5 15 15 71 71
+ 2 2 4 2 2 6 1 1 5 5 17 17 63 63
+ 2 2 4 2 2 6 1 1 5 5 17 17 65 65
+ 2 2 4 2 2 6 1 1 5 5 17 17 67 67
+ 2 2 4 2 2 6 1 1 5 5 17 17 69 69
+ 2 2 4 2 2 6 1 1 5 5 17 17 71 71
+ 2 2 4 2 2 6 1 1 5 5 19 19 63 63
+ 2 2 4 2 2 6 1 1 5 5 19 19 65 65
+ 2 2 4 2 2 6 1 1 5 5 19 19 67 67
+ 2 2 4 2 2 6 1 1 5 5 19 19 69 69
+ 2 2 4 2 2 6 1 1 5 5 19 19 71 71
+ 2 2 4 2 2 6 1 1 6 6 15 15 63 63
+ 2 2 4 2 2 6 1 1 6 6 15 15 65 65
+ 2 2 4 2 2 6 1 1 6 6 15 15 67 67
+ 2 2 4 2 2 6 1 1 6 6 15 15 69 69
+ 2 2 4 2 2 6 1 1 6 6 15 15 71 71
+ 2 2 4 2 2 6 1 1 6 6 17 17 63 63
+ 2 2 4 2 2 6 1 1 6 6 17 17 65 65
+ 2 2 4 2 2 6 1 1 6 6 17 17 67 67
+ 2 2 4 2 2 6 1 1 6 6 17 17 69 69
+ 2 2 4 2 2 6 1 1 6 6 17 17 71 71
+ 2 2 4 2 2 6 1 1 6 6 19 19 63 63
+ 2 2 4 2 2 6 1 1 6 6 19 19 65 65
+ 2 2 4 2 2 6 1 1 6 6 19 19 67 67
+ 2 2 4 2 2 6 1 1 6 6 19 19 69 69
+ 2 2 4 2 2 6 1 1 6 6 19 19 71 71
+ 2 2 4 2 2 6 2 2 4 4 15 15 63 63
+ 2 2 4 2 2 6 2 2 4 4 15 15 65 65
+ 2 2 4 2 2 6 2 2 4 4 15 15 67 67
+ 2 2 4 2 2 6 2 2 4 4 15 15 69 69
+ 2 2 4 2 2 6 2 2 4 4 15 15 71 71
+ 2 2 4 2 2 6 2 2 4 4 17 17 63 63
+ 2 2 4 2 2 6 2 2 4 4 17 17 65 65
+ 2 2 4 2 2 6 2 2 4 4 17 17 67 67
+ 2 2 4 2 2 6 2 2 4 4 17 17 69 69
+ 2 2 4 2 2 6 2 2 4 4 17 17 71 71
+ 2 2 4 2 2 6 2 2 4 4 19 19 63 63
+ 2 2 4 2 2 6 2 2 4 4 19 19 65 65
+ 2 2 4 2 2 6 2 2 4 4 19 19 67 67
+ 2 2 4 2 2 6 2 2 4 4 19 19 69 69
+ 2 2 4 2 2 6 2 2 4 4 19 19 71 71
+ 2 2 4 2 2 6 2 2 5 5 15 15 63 63
+ 2 2 4 2 2 6 2 2 5 5 15 15 65 65
+ 2 2 4 2 2 6 2 2 5 5 15 15 67 67
+ 2 2 4 2 2 6 2 2 5 5 15 15 69 69
+ 2 2 4 2 2 6 2 2 5 5 15 15 71 71
+ 2 2 4 2 2 6 2 2 5 5 17 17 63 63
+ 2 2 4 2 2 6 2 2 5 5 17 17 65 65
+ 2 2 4 2 2 6 2 2 5 5 17 17 67 67
+ 2 2 4 2 2 6 2 2 5 5 17 17 69 69
+ 2 2 4 2 2 6 2 2 5 5 17 17 71 71
+ 2 2 4 2 2 6 2 2 5 5 19 19 63 63
+ 2 2 4 2 2 6 2 2 5 5 19 19 65 65
+ 2 2 4 2 2 6 2 2 5 5 19 19 67 67
+ 2 2 4 2 2 6 2 2 5 5 19 19 69 69
+ 2 2 4 2 2 6 2 2 5 5 19 19 71 71
+ 2 2 4 2 2 6 2 2 6 6 15 15 63 63
+ 2 2 4 2 2 6 2 2 6 6 15 15 65 65
+ 2 2 4 2 2 6 2 2 6 6 15 15 67 67
+ 2 2 4 2 2 6 2 2 6 6 15 15 69 69
+ 2 2 4 2 2 6 2 2 6 6 15 15 71 71
+ 2 2 4 2 2 6 2 2 6 6 17 17 63 63
+ 2 2 4 2 2 6 2 2 6 6 17 17 65 65
+ 2 2 4 2 2 6 2 2 6 6 17 17 67 67
+ 2 2 4 2 2 6 2 2 6 6 17 17 69 69
+ 2 2 4 2 2 6 2 2 6 6 17 17 71 71
+ 2 2 4 2 2 6 2 2 6 6 19 19 63 63
+ 2 2 4 2 2 6 2 2 6 6 19 19 65 65
+ 2 2 4 2 2 6 2 2 6 6 19 19 67 67
+ 2 2 4 2 2 6 2 2 6 6 19 19 69 69
+ 2 2 4 2 2 6 2 2 6 6 19 19 71 71
+ 3 3 2 1 1 3 1 1 4 4 15 15 63 63
+ 3 3 2 1 1 3 1 1 4 4 15 15 65 65
+ 3 3 2 1 1 3 1 1 4 4 15 15 67 67
+ 3 3 2 1 1 3 1 1 4 4 15 15 69 69
+ 3 3 2 1 1 3 1 1 4 4 15 15 71 71
+ 3 3 2 1 1 3 1 1 4 4 17 17 63 63
+ 3 3 2 1 1 3 1 1 4 4 17 17 65 65
+ 3 3 2 1 1 3 1 1 4 4 17 17 67 67
+ 3 3 2 1 1 3 1 1 4 4 17 17 69 69
+ 3 3 2 1 1 3 1 1 4 4 17 17 71 71
+ 3 3 2 1 1 3 1 1 4 4 19 19 63 63
+ 3 3 2 1 1 3 1 1 4 4 19 19 65 65
+ 3 3 2 1 1 3 1 1 4 4 19 19 67 67
+ 3 3 2 1 1 3 1 1 4 4 19 19 69 69
+ 3 3 2 1 1 3 1 1 4 4 19 19 71 71
+ 3 3 2 1 1 3 1 1 5 5 15 15 63 63
+ 3 3 2 1 1 3 1 1 5 5 15 15 65 65
+ 3 3 2 1 1 3 1 1 5 5 15 15 67 67
+ 3 3 2 1 1 3 1 1 5 5 15 15 69 69
+ 3 3 2 1 1 3 1 1 5 5 15 15 71 71
+ 3 3 2 1 1 3 1 1 5 5 17 17 63 63
+ 3 3 2 1 1 3 1 1 5 5 17 17 65 65
+ 3 3 2 1 1 3 1 1 5 5 17 17 67 67
+ 3 3 2 1 1 3 1 1 5 5 17 17 69 69
+ 3 3 2 1 1 3 1 1 5 5 17 17 71 71
+ 3 3 2 1 1 3 1 1 5 5 19 19 63 63
+ 3 3 2 1 1 3 1 1 5 5 19 19 65 65
+ 3 3 2 1 1 3 1 1 5 5 19 19 67 67
+ 3 3 2 1 1 3 1 1 5 5 19 19 69 69
+ 3 3 2 1 1 3 1 1 5 5 19 19 71 71
+ 3 3 2 1 1 3 1 1 6 6 15 15 63 63
+ 3 3 2 1 1 3 1 1 6 6 15 15 65 65
+ 3 3 2 1 1 3 1 1 6 6 15 15 67 67
+ 3 3 2 1 1 3 1 1 6 6 15 15 69 69
+ 3 3 2 1 1 3 1 1 6 6 15 15 71 71
+ 3 3 2 1 1 3 1 1 6 6 17 17 63 63
+ 3 3 2 1 1 3 1 1 6 6 17 17 65 65
+ 3 3 2 1 1 3 1 1 6 6 17 17 67 67
+ 3 3 2 1 1 3 1 1 6 6 17 17 69 69
+ 3 3 2 1 1 3 1 1 6 6 17 17 71 71
+ 3 3 2 1 1 3 1 1 6 6 19 19 63 63
+ 3 3 2 1 1 3 1 1 6 6 19 19 65 65
+ 3 3 2 1 1 3 1 1 6 6 19 19 67 67
+ 3 3 2 1 1 3 1 1 6 6 19 19 69 69
+ 3 3 2 1 1 3 1 1 6 6 19 19 71 71
+ 3 3 2 1 1 3 2 2 4 4 15 15 63 63
+ 3 3 2 1 1 3 2 2 4 4 15 15 65 65
+ 3 3 2 1 1 3 2 2 4 4 15 15 67 67
+ 3 3 2 1 1 3 2 2 4 4 15 15 69 69
+ 3 3 2 1 1 3 2 2 4 4 15 15 71 71
+ 3 3 2 1 1 3 2 2 4 4 17 17 63 63
+ 3 3 2 1 1 3 2 2 4 4 17 17 65 65
+ 3 3 2 1 1 3 2 2 4 4 17 17 67 67
+ 3 3 2 1 1 3 2 2 4 4 17 17 69 69
+ 3 3 2 1 1 3 2 2 4 4 17 17 71 71
+ 3 3 2 1 1 3 2 2 4 4 19 19 63 63
+ 3 3 2 1 1 3 2 2 4 4 19 19 65 65
+ 3 3 2 1 1 3 2 2 4 4 19 19 67 67
+ 3 3 2 1 1 3 2 2 4 4 19 19 69 69
+ 3 3 2 1 1 3 2 2 4 4 19 19 71 71
+ 3 3 2 1 1 3 2 2 5 5 15 15 63 63
+ 3 3 2 1 1 3 2 2 5 5 15 15 65 65
+ 3 3 2 1 1 3 2 2 5 5 15 15 67 67
+ 3 3 2 1 1 3 2 2 5 5 15 15 69 69
+ 3 3 2 1 1 3 2 2 5 5 15 15 71 71
+ 3 3 2 1 1 3 2 2 5 5 17 17 63 63
+ 3 3 2 1 1 3 2 2 5 5 17 17 65 65
+ 3 3 2 1 1 3 2 2 5 5 17 17 67 67
+ 3 3 2 1 1 3 2 2 5 5 17 17 69 69
+ 3 3 2 1 1 3 2 2 5 5 17 17 71 71
+ 3 3 2 1 1 3 2 2 5 5 19 19 63 63
+ 3 3 2 1 1 3 2 2 5 5 19 19 65 65
+ 3 3 2 1 1 3 2 2 5 5 19 19 67 67
+ 3 3 2 1 1 3 2 2 5 5 19 19 69 69
+ 3 3 2 1 1 3 2 2 5 5 19 19 71 71
+ 3 3 2 1 1 3 2 2 6 6 15 15 63 63
+ 3 3 2 1 1 3 2 2 6 6 15 15 65 65
+ 3 3 2 1 1 3 2 2 6 6 15 15 67 67
+ 3 3 2 1 1 3 2 2 6 6 15 15 69 69
+ 3 3 2 1 1 3 2 2 6 6 15 15 71 71
+ 3 3 2 1 1 3 2 2 6 6 17 17 63 63
+ 3 3 2 1 1 3 2 2 6 6 17 17 65 65
+ 3 3 2 1 1 3 2 2 6 6 17 17 67 67
+ 3 3 2 1 1 3 2 2 6 6 17 17 69 69
+ 3 3 2 1 1 3 2 2 6 6 17 17 71 71
+ 3 3 2 1 1 3 2 2 6 6 19 19 63 63
+ 3 3 2 1 1 3 2 2 6 6 19 19 65 65
+ 3 3 2 1 1 3 2 2 6 6 19 19 67 67
+ 3 3 2 1 1 3 2 2 6 6 19 19 69 69
+ 3 3 2 1 1 3 2 2 6 6 19 19 71 71
+ 3 3 2 1 2 6 1 1 4 4 15 15 63 63
+ 3 3 2 1 2 6 1 1 4 4 15 15 65 65
+ 3 3 2 1 2 6 1 1 4 4 15 15 67 67
+ 3 3 2 1 2 6 1 1 4 4 15 15 69 69
+ 3 3 2 1 2 6 1 1 4 4 15 15 71 71
+ 3 3 2 1 2 6 1 1 4 4 17 17 63 63
+ 3 3 2 1 2 6 1 1 4 4 17 17 65 65
+ 3 3 2 1 2 6 1 1 4 4 17 17 67 67
+ 3 3 2 1 2 6 1 1 4 4 17 17 69 69
+ 3 3 2 1 2 6 1 1 4 4 17 17 71 71
+ 3 3 2 1 2 6 1 1 4 4 19 19 63 63
+ 3 3 2 1 2 6 1 1 4 4 19 19 65 65
+ 3 3 2 1 2 6 1 1 4 4 19 19 67 67
+ 3 3 2 1 2 6 1 1 4 4 19 19 69 69
+ 3 3 2 1 2 6 1 1 4 4 19 19 71 71
+ 3 3 2 1 2 6 1 1 5 5 15 15 63 63
+ 3 3 2 1 2 6 1 1 5 5 15 15 65 65
+ 3 3 2 1 2 6 1 1 5 5 15 15 67 67
+ 3 3 2 1 2 6 1 1 5 5 15 15 69 69
+ 3 3 2 1 2 6 1 1 5 5 15 15 71 71
+ 3 3 2 1 2 6 1 1 5 5 17 17 63 63
+ 3 3 2 1 2 6 1 1 5 5 17 17 65 65
+ 3 3 2 1 2 6 1 1 5 5 17 17 67 67
+ 3 3 2 1 2 6 1 1 5 5 17 17 69 69
+ 3 3 2 1 2 6 1 1 5 5 17 17 71 71
+ 3 3 2 1 2 6 1 1 5 5 19 19 63 63
+ 3 3 2 1 2 6 1 1 5 5 19 19 65 65
+ 3 3 2 1 2 6 1 1 5 5 19 19 67 67
+ 3 3 2 1 2 6 1 1 5 5 19 19 69 69
+ 3 3 2 1 2 6 1 1 5 5 19 19 71 71
+ 3 3 2 1 2 6 1 1 6 6 15 15 63 63
+ 3 3 2 1 2 6 1 1 6 6 15 15 65 65
+ 3 3 2 1 2 6 1 1 6 6 15 15 67 67
+ 3 3 2 1 2 6 1 1 6 6 15 15 69 69
+ 3 3 2 1 2 6 1 1 6 6 15 15 71 71
+ 3 3 2 1 2 6 1 1 6 6 17 17 63 63
+ 3 3 2 1 2 6 1 1 6 6 17 17 65 65
+ 3 3 2 1 2 6 1 1 6 6 17 17 67 67
+ 3 3 2 1 2 6 1 1 6 6 17 17 69 69
+ 3 3 2 1 2 6 1 1 6 6 17 17 71 71
+ 3 3 2 1 2 6 1 1 6 6 19 19 63 63
+ 3 3 2 1 2 6 1 1 6 6 19 19 65 65
+ 3 3 2 1 2 6 1 1 6 6 19 19 67 67
+ 3 3 2 1 2 6 1 1 6 6 19 19 69 69
+ 3 3 2 1 2 6 1 1 6 6 19 19 71 71
+ 3 3 2 1 2 6 2 2 4 4 15 15 63 63
+ 3 3 2 1 2 6 2 2 4 4 15 15 65 65
+ 3 3 2 1 2 6 2 2 4 4 15 15 67 67
+ 3 3 2 1 2 6 2 2 4 4 15 15 69 69
+ 3 3 2 1 2 6 2 2 4 4 15 15 71 71
+ 3 3 2 1 2 6 2 2 4 4 17 17 63 63
+ 3 3 2 1 2 6 2 2 4 4 17 17 65 65
+ 3 3 2 1 2 6 2 2 4 4 17 17 67 67
+ 3 3 2 1 2 6 2 2 4 4 17 17 69 69
+ 3 3 2 1 2 6 2 2 4 4 17 17 71 71
+ 3 3 2 1 2 6 2 2 4 4 19 19 63 63
+ 3 3 2 1 2 6 2 2 4 4 19 19 65 65
+ 3 3 2 1 2 6 2 2 4 4 19 19 67 67
+ 3 3 2 1 2 6 2 2 4 4 19 19 69 69
+ 3 3 2 1 2 6 2 2 4 4 19 19 71 71
+ 3 3 2 1 2 6 2 2 5 5 15 15 63 63
+ 3 3 2 1 2 6 2 2 5 5 15 15 65 65
+ 3 3 2 1 2 6 2 2 5 5 15 15 67 67
+ 3 3 2 1 2 6 2 2 5 5 15 15 69 69
+ 3 3 2 1 2 6 2 2 5 5 15 15 71 71
+ 3 3 2 1 2 6 2 2 5 5 17 17 63 63
+ 3 3 2 1 2 6 2 2 5 5 17 17 65 65
+ 3 3 2 1 2 6 2 2 5 5 17 17 67 67
+ 3 3 2 1 2 6 2 2 5 5 17 17 69 69
+ 3 3 2 1 2 6 2 2 5 5 17 17 71 71
+ 3 3 2 1 2 6 2 2 5 5 19 19 63 63
+ 3 3 2 1 2 6 2 2 5 5 19 19 65 65
+ 3 3 2 1 2 6 2 2 5 5 19 19 67 67
+ 3 3 2 1 2 6 2 2 5 5 19 19 69 69
+ 3 3 2 1 2 6 2 2 5 5 19 19 71 71
+ 3 3 2 1 2 6 2 2 6 6 15 15 63 63
+ 3 3 2 1 2 6 2 2 6 6 15 15 65 65
+ 3 3 2 1 2 6 2 2 6 6 15 15 67 67
+ 3 3 2 1 2 6 2 2 6 6 15 15 69 69
+ 3 3 2 1 2 6 2 2 6 6 15 15 71 71
+ 3 3 2 1 2 6 2 2 6 6 17 17 63 63
+ 3 3 2 1 2 6 2 2 6 6 17 17 65 65
+ 3 3 2 1 2 6 2 2 6 6 17 17 67 67
+ 3 3 2 1 2 6 2 2 6 6 17 17 69 69
+ 3 3 2 1 2 6 2 2 6 6 17 17 71 71
+ 3 3 2 1 2 6 2 2 6 6 19 19 63 63
+ 3 3 2 1 2 6 2 2 6 6 19 19 65 65
+ 3 3 2 1 2 6 2 2 6 6 19 19 67 67
+ 3 3 2 1 2 6 2 2 6 6 19 19 69 69
+ 3 3 2 1 2 6 2 2 6 6 19 19 71 71
+ 3 3 3 2 1 3 1 1 4 4 15 15 63 63
+ 3 3 3 2 1 3 1 1 4 4 15 15 65 65
+ 3 3 3 2 1 3 1 1 4 4 15 15 67 67
+ 3 3 3 2 1 3 1 1 4 4 15 15 69 69
+ 3 3 3 2 1 3 1 1 4 4 15 15 71 71
+ 3 3 3 2 1 3 1 1 4 4 17 17 63 63
+ 3 3 3 2 1 3 1 1 4 4 17 17 65 65
+ 3 3 3 2 1 3 1 1 4 4 17 17 67 67
+ 3 3 3 2 1 3 1 1 4 4 17 17 69 69
+ 3 3 3 2 1 3 1 1 4 4 17 17 71 71
+ 3 3 3 2 1 3 1 1 4 4 19 19 63 63
+ 3 3 3 2 1 3 1 1 4 4 19 19 65 65
+ 3 3 3 2 1 3 1 1 4 4 19 19 67 67
+ 3 3 3 2 1 3 1 1 4 4 19 19 69 69
+ 3 3 3 2 1 3 1 1 4 4 19 19 71 71
+ 3 3 3 2 1 3 1 1 5 5 15 15 63 63
+ 3 3 3 2 1 3 1 1 5 5 15 15 65 65
+ 3 3 3 2 1 3 1 1 5 5 15 15 67 67
+ 3 3 3 2 1 3 1 1 5 5 15 15 69 69
+ 3 3 3 2 1 3 1 1 5 5 15 15 71 71
+ 3 3 3 2 1 3 1 1 5 5 17 17 63 63
+ 3 3 3 2 1 3 1 1 5 5 17 17 65 65
+ 3 3 3 2 1 3 1 1 5 5 17 17 67 67
+ 3 3 3 2 1 3 1 1 5 5 17 17 69 69
+ 3 3 3 2 1 3 1 1 5 5 17 17 71 71
+ 3 3 3 2 1 3 1 1 5 5 19 19 63 63
+ 3 3 3 2 1 3 1 1 5 5 19 19 65 65
+ 3 3 3 2 1 3 1 1 5 5 19 19 67 67
+ 3 3 3 2 1 3 1 1 5 5 19 19 69 69
+ 3 3 3 2 1 3 1 1 5 5 19 19 71 71
+ 3 3 3 2 1 3 1 1 6 6 15 15 63 63
+ 3 3 3 2 1 3 1 1 6 6 15 15 65 65
+ 3 3 3 2 1 3 1 1 6 6 15 15 67 67
+ 3 3 3 2 1 3 1 1 6 6 15 15 69 69
+ 3 3 3 2 1 3 1 1 6 6 15 15 71 71
+ 3 3 3 2 1 3 1 1 6 6 17 17 63 63
+ 3 3 3 2 1 3 1 1 6 6 17 17 65 65
+ 3 3 3 2 1 3 1 1 6 6 17 17 67 67
+ 3 3 3 2 1 3 1 1 6 6 17 17 69 69
+ 3 3 3 2 1 3 1 1 6 6 17 17 71 71
+ 3 3 3 2 1 3 1 1 6 6 19 19 63 63
+ 3 3 3 2 1 3 1 1 6 6 19 19 65 65
+ 3 3 3 2 1 3 1 1 6 6 19 19 67 67
+ 3 3 3 2 1 3 1 1 6 6 19 19 69 69
+ 3 3 3 2 1 3 1 1 6 6 19 19 71 71
+ 3 3 3 2 1 3 2 2 4 4 15 15 63 63
+ 3 3 3 2 1 3 2 2 4 4 15 15 65 65
+ 3 3 3 2 1 3 2 2 4 4 15 15 67 67
+ 3 3 3 2 1 3 2 2 4 4 15 15 69 69
+ 3 3 3 2 1 3 2 2 4 4 15 15 71 71
+ 3 3 3 2 1 3 2 2 4 4 17 17 63 63
+ 3 3 3 2 1 3 2 2 4 4 17 17 65 65
+ 3 3 3 2 1 3 2 2 4 4 17 17 67 67
+ 3 3 3 2 1 3 2 2 4 4 17 17 69 69
+ 3 3 3 2 1 3 2 2 4 4 17 17 71 71
+ 3 3 3 2 1 3 2 2 4 4 19 19 63 63
+ 3 3 3 2 1 3 2 2 4 4 19 19 65 65
+ 3 3 3 2 1 3 2 2 4 4 19 19 67 67
+ 3 3 3 2 1 3 2 2 4 4 19 19 69 69
+ 3 3 3 2 1 3 2 2 4 4 19 19 71 71
+ 3 3 3 2 1 3 2 2 5 5 15 15 63 63
+ 3 3 3 2 1 3 2 2 5 5 15 15 65 65
+ 3 3 3 2 1 3 2 2 5 5 15 15 67 67
+ 3 3 3 2 1 3 2 2 5 5 15 15 69 69
+ 3 3 3 2 1 3 2 2 5 5 15 15 71 71
+ 3 3 3 2 1 3 2 2 5 5 17 17 63 63
+ 3 3 3 2 1 3 2 2 5 5 17 17 65 65
+ 3 3 3 2 1 3 2 2 5 5 17 17 67 67
+ 3 3 3 2 1 3 2 2 5 5 17 17 69 69
+ 3 3 3 2 1 3 2 2 5 5 17 17 71 71
+ 3 3 3 2 1 3 2 2 5 5 19 19 63 63
+ 3 3 3 2 1 3 2 2 5 5 19 19 65 65
+ 3 3 3 2 1 3 2 2 5 5 19 19 67 67
+ 3 3 3 2 1 3 2 2 5 5 19 19 69 69
+ 3 3 3 2 1 3 2 2 5 5 19 19 71 71
+ 3 3 3 2 1 3 2 2 6 6 15 15 63 63
+ 3 3 3 2 1 3 2 2 6 6 15 15 65 65
+ 3 3 3 2 1 3 2 2 6 6 15 15 67 67
+ 3 3 3 2 1 3 2 2 6 6 15 15 69 69
+ 3 3 3 2 1 3 2 2 6 6 15 15 71 71
+ 3 3 3 2 1 3 2 2 6 6 17 17 63 63
+ 3 3 3 2 1 3 2 2 6 6 17 17 65 65
+ 3 3 3 2 1 3 2 2 6 6 17 17 67 67
+ 3 3 3 2 1 3 2 2 6 6 17 17 69 69
+ 3 3 3 2 1 3 2 2 6 6 17 17 71 71
+ 3 3 3 2 1 3 2 2 6 6 19 19 63 63
+ 3 3 3 2 1 3 2 2 6 6 19 19 65 65
+ 3 3 3 2 1 3 2 2 6 6 19 19 67 67
+ 3 3 3 2 1 3 2 2 6 6 19 19 69 69
+ 3 3 3 2 1 3 2 2 6 6 19 19 71 71
+ 3 3 3 2 2 6 1 1 4 4 15 15 63 63
+ 3 3 3 2 2 6 1 1 4 4 15 15 65 65
+ 3 3 3 2 2 6 1 1 4 4 15 15 67 67
+ 3 3 3 2 2 6 1 1 4 4 15 15 69 69
+ 3 3 3 2 2 6 1 1 4 4 15 15 71 71
+ 3 3 3 2 2 6 1 1 4 4 17 17 63 63
+ 3 3 3 2 2 6 1 1 4 4 17 17 65 65
+ 3 3 3 2 2 6 1 1 4 4 17 17 67 67
+ 3 3 3 2 2 6 1 1 4 4 17 17 69 69
+ 3 3 3 2 2 6 1 1 4 4 17 17 71 71
+ 3 3 3 2 2 6 1 1 4 4 19 19 63 63
+ 3 3 3 2 2 6 1 1 4 4 19 19 65 65
+ 3 3 3 2 2 6 1 1 4 4 19 19 67 67
+ 3 3 3 2 2 6 1 1 4 4 19 19 69 69
+ 3 3 3 2 2 6 1 1 4 4 19 19 71 71
+ 3 3 3 2 2 6 1 1 5 5 15 15 63 63
+ 3 3 3 2 2 6 1 1 5 5 15 15 65 65
+ 3 3 3 2 2 6 1 1 5 5 15 15 67 67
+ 3 3 3 2 2 6 1 1 5 5 15 15 69 69
+ 3 3 3 2 2 6 1 1 5 5 15 15 71 71
+ 3 3 3 2 2 6 1 1 5 5 17 17 63 63
+ 3 3 3 2 2 6 1 1 5 5 17 17 65 65
+ 3 3 3 2 2 6 1 1 5 5 17 17 67 67
+ 3 3 3 2 2 6 1 1 5 5 17 17 69 69
+ 3 3 3 2 2 6 1 1 5 5 17 17 71 71
+ 3 3 3 2 2 6 1 1 5 5 19 19 63 63
+ 3 3 3 2 2 6 1 1 5 5 19 19 65 65
+ 3 3 3 2 2 6 1 1 5 5 19 19 67 67
+ 3 3 3 2 2 6 1 1 5 5 19 19 69 69
+ 3 3 3 2 2 6 1 1 5 5 19 19 71 71
+ 3 3 3 2 2 6 1 1 6 6 15 15 63 63
+ 3 3 3 2 2 6 1 1 6 6 15 15 65 65
+ 3 3 3 2 2 6 1 1 6 6 15 15 67 67
+ 3 3 3 2 2 6 1 1 6 6 15 15 69 69
+ 3 3 3 2 2 6 1 1 6 6 15 15 71 71
+ 3 3 3 2 2 6 1 1 6 6 17 17 63 63
+ 3 3 3 2 2 6 1 1 6 6 17 17 65 65
+ 3 3 3 2 2 6 1 1 6 6 17 17 67 67
+ 3 3 3 2 2 6 1 1 6 6 17 17 69 69
+ 3 3 3 2 2 6 1 1 6 6 17 17 71 71
+ 3 3 3 2 2 6 1 1 6 6 19 19 63 63
+ 3 3 3 2 2 6 1 1 6 6 19 19 65 65
+ 3 3 3 2 2 6 1 1 6 6 19 19 67 67
+ 3 3 3 2 2 6 1 1 6 6 19 19 69 69
+ 3 3 3 2 2 6 1 1 6 6 19 19 71 71
+ 3 3 3 2 2 6 2 2 4 4 15 15 63 63
+ 3 3 3 2 2 6 2 2 4 4 15 15 65 65
+ 3 3 3 2 2 6 2 2 4 4 15 15 67 67
+ 3 3 3 2 2 6 2 2 4 4 15 15 69 69
+ 3 3 3 2 2 6 2 2 4 4 15 15 71 71
+ 3 3 3 2 2 6 2 2 4 4 17 17 63 63
+ 3 3 3 2 2 6 2 2 4 4 17 17 65 65
+ 3 3 3 2 2 6 2 2 4 4 17 17 67 67
+ 3 3 3 2 2 6 2 2 4 4 17 17 69 69
+ 3 3 3 2 2 6 2 2 4 4 17 17 71 71
+ 3 3 3 2 2 6 2 2 4 4 19 19 63 63
+ 3 3 3 2 2 6 2 2 4 4 19 19 65 65
+ 3 3 3 2 2 6 2 2 4 4 19 19 67 67
+ 3 3 3 2 2 6 2 2 4 4 19 19 69 69
+ 3 3 3 2 2 6 2 2 4 4 19 19 71 71
+ 3 3 3 2 2 6 2 2 5 5 15 15 63 63
+ 3 3 3 2 2 6 2 2 5 5 15 15 65 65
+ 3 3 3 2 2 6 2 2 5 5 15 15 67 67
+ 3 3 3 2 2 6 2 2 5 5 15 15 69 69
+ 3 3 3 2 2 6 2 2 5 5 15 15 71 71
+ 3 3 3 2 2 6 2 2 5 5 17 17 63 63
+ 3 3 3 2 2 6 2 2 5 5 17 17 65 65
+ 3 3 3 2 2 6 2 2 5 5 17 17 67 67
+ 3 3 3 2 2 6 2 2 5 5 17 17 69 69
+ 3 3 3 2 2 6 2 2 5 5 17 17 71 71
+ 3 3 3 2 2 6 2 2 5 5 19 19 63 63
+ 3 3 3 2 2 6 2 2 5 5 19 19 65 65
+ 3 3 3 2 2 6 2 2 5 5 19 19 67 67
+ 3 3 3 2 2 6 2 2 5 5 19 19 69 69
+ 3 3 3 2 2 6 2 2 5 5 19 19 71 71
+ 3 3 3 2 2 6 2 2 6 6 15 15 63 63
+ 3 3 3 2 2 6 2 2 6 6 15 15 65 65
+ 3 3 3 2 2 6 2 2 6 6 15 15 67 67
+ 3 3 3 2 2 6 2 2 6 6 15 15 69 69
+ 3 3 3 2 2 6 2 2 6 6 15 15 71 71
+ 3 3 3 2 2 6 2 2 6 6 17 17 63 63
+ 3 3 3 2 2 6 2 2 6 6 17 17 65 65
+ 3 3 3 2 2 6 2 2 6 6 17 17 67 67
+ 3 3 3 2 2 6 2 2 6 6 17 17 69 69
+ 3 3 3 2 2 6 2 2 6 6 17 17 71 71
+ 3 3 3 2 2 6 2 2 6 6 19 19 63 63
+ 3 3 3 2 2 6 2 2 6 6 19 19 65 65
+ 3 3 3 2 2 6 2 2 6 6 19 19 67 67
+ 3 3 3 2 2 6 2 2 6 6 19 19 69 69
+ 3 3 3 2 2 6 2 2 6 6 19 19 71 71
+ 3 3 4 2 1 3 1 1 4 4 15 15 63 63
+ 3 3 4 2 1 3 1 1 4 4 15 15 65 65
+ 3 3 4 2 1 3 1 1 4 4 15 15 67 67
+ 3 3 4 2 1 3 1 1 4 4 15 15 69 69
+ 3 3 4 2 1 3 1 1 4 4 15 15 71 71
+ 3 3 4 2 1 3 1 1 4 4 17 17 63 63
+ 3 3 4 2 1 3 1 1 4 4 17 17 65 65
+ 3 3 4 2 1 3 1 1 4 4 17 17 67 67
+ 3 3 4 2 1 3 1 1 4 4 17 17 69 69
+ 3 3 4 2 1 3 1 1 4 4 17 17 71 71
+ 3 3 4 2 1 3 1 1 4 4 19 19 63 63
+ 3 3 4 2 1 3 1 1 4 4 19 19 65 65
+ 3 3 4 2 1 3 1 1 4 4 19 19 67 67
+ 3 3 4 2 1 3 1 1 4 4 19 19 69 69
+ 3 3 4 2 1 3 1 1 4 4 19 19 71 71
+ 3 3 4 2 1 3 1 1 5 5 15 15 63 63
+ 3 3 4 2 1 3 1 1 5 5 15 15 65 65
+ 3 3 4 2 1 3 1 1 5 5 15 15 67 67
+ 3 3 4 2 1 3 1 1 5 5 15 15 69 69
+ 3 3 4 2 1 3 1 1 5 5 15 15 71 71
+ 3 3 4 2 1 3 1 1 5 5 17 17 63 63
+ 3 3 4 2 1 3 1 1 5 5 17 17 65 65
+ 3 3 4 2 1 3 1 1 5 5 17 17 67 67
+ 3 3 4 2 1 3 1 1 5 5 17 17 69 69
+ 3 3 4 2 1 3 1 1 5 5 17 17 71 71
+ 3 3 4 2 1 3 1 1 5 5 19 19 63 63
+ 3 3 4 2 1 3 1 1 5 5 19 19 65 65
+ 3 3 4 2 1 3 1 1 5 5 19 19 67 67
+ 3 3 4 2 1 3 1 1 5 5 19 19 69 69
+ 3 3 4 2 1 3 1 1 5 5 19 19 71 71
+ 3 3 4 2 1 3 1 1 6 6 15 15 63 63
+ 3 3 4 2 1 3 1 1 6 6 15 15 65 65
+ 3 3 4 2 1 3 1 1 6 6 15 15 67 67
+ 3 3 4 2 1 3 1 1 6 6 15 15 69 69
+ 3 3 4 2 1 3 1 1 6 6 15 15 71 71
+ 3 3 4 2 1 3 1 1 6 6 17 17 63 63
+ 3 3 4 2 1 3 1 1 6 6 17 17 65 65
+ 3 3 4 2 1 3 1 1 6 6 17 17 67 67
+ 3 3 4 2 1 3 1 1 6 6 17 17 69 69
+ 3 3 4 2 1 3 1 1 6 6 17 17 71 71
+ 3 3 4 2 1 3 1 1 6 6 19 19 63 63
+ 3 3 4 2 1 3 1 1 6 6 19 19 65 65
+ 3 3 4 2 1 3 1 1 6 6 19 19 67 67
+ 3 3 4 2 1 3 1 1 6 6 19 19 69 69
+ 3 3 4 2 1 3 1 1 6 6 19 19 71 71
+ 3 3 4 2 1 3 2 2 4 4 15 15 63 63
+ 3 3 4 2 1 3 2 2 4 4 15 15 65 65
+ 3 3 4 2 1 3 2 2 4 4 15 15 67 67
+ 3 3 4 2 1 3 2 2 4 4 15 15 69 69
+ 3 3 4 2 1 3 2 2 4 4 15 15 71 71
+ 3 3 4 2 1 3 2 2 4 4 17 17 63 63
+ 3 3 4 2 1 3 2 2 4 4 17 17 65 65
+ 3 3 4 2 1 3 2 2 4 4 17 17 67 67
+ 3 3 4 2 1 3 2 2 4 4 17 17 69 69
+ 3 3 4 2 1 3 2 2 4 4 17 17 71 71
+ 3 3 4 2 1 3 2 2 4 4 19 19 63 63
+ 3 3 4 2 1 3 2 2 4 4 19 19 65 65
+ 3 3 4 2 1 3 2 2 4 4 19 19 67 67
+ 3 3 4 2 1 3 2 2 4 4 19 19 69 69
+ 3 3 4 2 1 3 2 2 4 4 19 19 71 71
+ 3 3 4 2 1 3 2 2 5 5 15 15 63 63
+ 3 3 4 2 1 3 2 2 5 5 15 15 65 65
+ 3 3 4 2 1 3 2 2 5 5 15 15 67 67
+ 3 3 4 2 1 3 2 2 5 5 15 15 69 69
+ 3 3 4 2 1 3 2 2 5 5 15 15 71 71
+ 3 3 4 2 1 3 2 2 5 5 17 17 63 63
+ 3 3 4 2 1 3 2 2 5 5 17 17 65 65
+ 3 3 4 2 1 3 2 2 5 5 17 17 67 67
+ 3 3 4 2 1 3 2 2 5 5 17 17 69 69
+ 3 3 4 2 1 3 2 2 5 5 17 17 71 71
+ 3 3 4 2 1 3 2 2 5 5 19 19 63 63
+ 3 3 4 2 1 3 2 2 5 5 19 19 65 65
+ 3 3 4 2 1 3 2 2 5 5 19 19 67 67
+ 3 3 4 2 1 3 2 2 5 5 19 19 69 69
+ 3 3 4 2 1 3 2 2 5 5 19 19 71 71
+ 3 3 4 2 1 3 2 2 6 6 15 15 63 63
+ 3 3 4 2 1 3 2 2 6 6 15 15 65 65
+ 3 3 4 2 1 3 2 2 6 6 15 15 67 67
+ 3 3 4 2 1 3 2 2 6 6 15 15 69 69
+ 3 3 4 2 1 3 2 2 6 6 15 15 71 71
+ 3 3 4 2 1 3 2 2 6 6 17 17 63 63
+ 3 3 4 2 1 3 2 2 6 6 17 17 65 65
+ 3 3 4 2 1 3 2 2 6 6 17 17 67 67
+ 3 3 4 2 1 3 2 2 6 6 17 17 69 69
+ 3 3 4 2 1 3 2 2 6 6 17 17 71 71
+ 3 3 4 2 1 3 2 2 6 6 19 19 63 63
+ 3 3 4 2 1 3 2 2 6 6 19 19 65 65
+ 3 3 4 2 1 3 2 2 6 6 19 19 67 67
+ 3 3 4 2 1 3 2 2 6 6 19 19 69 69
+ 3 3 4 2 1 3 2 2 6 6 19 19 71 71
+ 3 3 4 2 2 6 1 1 4 4 15 15 63 63
+ 3 3 4 2 2 6 1 1 4 4 15 15 65 65
+ 3 3 4 2 2 6 1 1 4 4 15 15 67 67
+ 3 3 4 2 2 6 1 1 4 4 15 15 69 69
+ 3 3 4 2 2 6 1 1 4 4 15 15 71 71
+ 3 3 4 2 2 6 1 1 4 4 17 17 63 63
+ 3 3 4 2 2 6 1 1 4 4 17 17 65 65
+ 3 3 4 2 2 6 1 1 4 4 17 17 67 67
+ 3 3 4 2 2 6 1 1 4 4 17 17 69 69
+ 3 3 4 2 2 6 1 1 4 4 17 17 71 71
+ 3 3 4 2 2 6 1 1 4 4 19 19 63 63
+ 3 3 4 2 2 6 1 1 4 4 19 19 65 65
+ 3 3 4 2 2 6 1 1 4 4 19 19 67 67
+ 3 3 4 2 2 6 1 1 4 4 19 19 69 69
+ 3 3 4 2 2 6 1 1 4 4 19 19 71 71
+ 3 3 4 2 2 6 1 1 5 5 15 15 63 63
+ 3 3 4 2 2 6 1 1 5 5 15 15 65 65
+ 3 3 4 2 2 6 1 1 5 5 15 15 67 67
+ 3 3 4 2 2 6 1 1 5 5 15 15 69 69
+ 3 3 4 2 2 6 1 1 5 5 15 15 71 71
+ 3 3 4 2 2 6 1 1 5 5 17 17 63 63
+ 3 3 4 2 2 6 1 1 5 5 17 17 65 65
+ 3 3 4 2 2 6 1 1 5 5 17 17 67 67
+ 3 3 4 2 2 6 1 1 5 5 17 17 69 69
+ 3 3 4 2 2 6 1 1 5 5 17 17 71 71
+ 3 3 4 2 2 6 1 1 5 5 19 19 63 63
+ 3 3 4 2 2 6 1 1 5 5 19 19 65 65
+ 3 3 4 2 2 6 1 1 5 5 19 19 67 67
+ 3 3 4 2 2 6 1 1 5 5 19 19 69 69
+ 3 3 4 2 2 6 1 1 5 5 19 19 71 71
+ 3 3 4 2 2 6 1 1 6 6 15 15 63 63
+ 3 3 4 2 2 6 1 1 6 6 15 15 65 65
+ 3 3 4 2 2 6 1 1 6 6 15 15 67 67
+ 3 3 4 2 2 6 1 1 6 6 15 15 69 69
+ 3 3 4 2 2 6 1 1 6 6 15 15 71 71
+ 3 3 4 2 2 6 1 1 6 6 17 17 63 63
+ 3 3 4 2 2 6 1 1 6 6 17 17 65 65
+ 3 3 4 2 2 6 1 1 6 6 17 17 67 67
+ 3 3 4 2 2 6 1 1 6 6 17 17 69 69
+ 3 3 4 2 2 6 1 1 6 6 17 17 71 71
+ 3 3 4 2 2 6 1 1 6 6 19 19 63 63
+ 3 3 4 2 2 6 1 1 6 6 19 19 65 65
+ 3 3 4 2 2 6 1 1 6 6 19 19 67 67
+ 3 3 4 2 2 6 1 1 6 6 19 19 69 69
+ 3 3 4 2 2 6 1 1 6 6 19 19 71 71
+ 3 3 4 2 2 6 2 2 4 4 15 15 63 63
+ 3 3 4 2 2 6 2 2 4 4 15 15 65 65
+ 3 3 4 2 2 6 2 2 4 4 15 15 67 67
+ 3 3 4 2 2 6 2 2 4 4 15 15 69 69
+ 3 3 4 2 2 6 2 2 4 4 15 15 71 71
+ 3 3 4 2 2 6 2 2 4 4 17 17 63 63
+ 3 3 4 2 2 6 2 2 4 4 17 17 65 65
+ 3 3 4 2 2 6 2 2 4 4 17 17 67 67
+ 3 3 4 2 2 6 2 2 4 4 17 17 69 69
+ 3 3 4 2 2 6 2 2 4 4 17 17 71 71
+ 3 3 4 2 2 6 2 2 4 4 19 19 63 63
+ 3 3 4 2 2 6 2 2 4 4 19 19 65 65
+ 3 3 4 2 2 6 2 2 4 4 19 19 67 67
+ 3 3 4 2 2 6 2 2 4 4 19 19 69 69
+ 3 3 4 2 2 6 2 2 4 4 19 19 71 71
+ 3 3 4 2 2 6 2 2 5 5 15 15 63 63
+ 3 3 4 2 2 6 2 2 5 5 15 15 65 65
+ 3 3 4 2 2 6 2 2 5 5 15 15 67 67
+ 3 3 4 2 2 6 2 2 5 5 15 15 69 69
+ 3 3 4 2 2 6 2 2 5 5 15 15 71 71
+ 3 3 4 2 2 6 2 2 5 5 17 17 63 63
+ 3 3 4 2 2 6 2 2 5 5 17 17 65 65
+ 3 3 4 2 2 6 2 2 5 5 17 17 67 67
+ 3 3 4 2 2 6 2 2 5 5 17 17 69 69
+ 3 3 4 2 2 6 2 2 5 5 17 17 71 71
+ 3 3 4 2 2 6 2 2 5 5 19 19 63 63
+ 3 3 4 2 2 6 2 2 5 5 19 19 65 65
+ 3 3 4 2 2 6 2 2 5 5 19 19 67 67
+ 3 3 4 2 2 6 2 2 5 5 19 19 69 69
+ 3 3 4 2 2 6 2 2 5 5 19 19 71 71
+ 3 3 4 2 2 6 2 2 6 6 15 15 63 63
+ 3 3 4 2 2 6 2 2 6 6 15 15 65 65
+ 3 3 4 2 2 6 2 2 6 6 15 15 67 67
+ 3 3 4 2 2 6 2 2 6 6 15 15 69 69
+ 3 3 4 2 2 6 2 2 6 6 15 15 71 71
+ 3 3 4 2 2 6 2 2 6 6 17 17 63 63
+ 3 3 4 2 2 6 2 2 6 6 17 17 65 65
+ 3 3 4 2 2 6 2 2 6 6 17 17 67 67
+ 3 3 4 2 2 6 2 2 6 6 17 17 69 69
+ 3 3 4 2 2 6 2 2 6 6 17 17 71 71
+ 3 3 4 2 2 6 2 2 6 6 19 19 63 63
+ 3 3 4 2 2 6 2 2 6 6 19 19 65 65
+ 3 3 4 2 2 6 2 2 6 6 19 19 67 67
+ 3 3 4 2 2 6 2 2 6 6 19 19 69 69
+ 3 3 4 2 2 6 2 2 6 6 19 19 71 71

.tran 1p 10n sweep data = sweepdata
.measure tran tpLH TRIG V(NA1) = '0.5*SUPPLY' FALL = 4 TARG V(buffer_out_3) = '0.5*SUPPLY' RISE = 4
.measure tran tpHL TRIG V(NA1) = '0.5*SUPPLY' RISE = 4 TARG V(buffer_out_3) = '0.5*SUPPLY' FALL = 4

.measure tran tp param='(tpLH+tpHL)/2'
.end
